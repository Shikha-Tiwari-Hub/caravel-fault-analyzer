* NGSPICE file created from user_project_wrapper.ext - technology: sky130A

.subckt X2_sky130_fd_sc_hd__diode_2 DIODE VGND VPWR VPB VNB
X0 VNB DIODE sky130_fd_pr__diode_pw2nd_05v5 perim=2.64e+06 area=4.347e+11
.ends

* Black-box entry subcircuit for X2_sky130_fd_sc_hd__fill_1 abstract view
.subckt X2_sky130_fd_sc_hd__fill_1 VPWR VGND VPB VNB
.ends

* Black-box entry subcircuit for X2_sky130_fd_sc_hd__fill_4 abstract view
.subckt X2_sky130_fd_sc_hd__fill_4 VGND VPWR VPB VNB
.ends

.subckt X2_sky130_ef_sc_hd__decap_40_12 VNB VPB VGND VPWR
X0 VPWR VGND VPWR VPB sky130_fd_pr__pfet_01v8_hvt ad=0.7482 pd=3.46 as=0 ps=0 w=0.87 l=1.65
X1 VGND VPWR VGND VNB sky130_fd_pr__nfet_01v8 ad=1.496 pd=6.54 as=0 ps=0 w=0.55 l=1.6
.ends

* Black-box entry subcircuit for X2_sky130_fd_sc_hd__fill_2 abstract view
.subckt X2_sky130_fd_sc_hd__fill_2 VGND VPWR VPB VNB
.ends

* Black-box entry subcircuit for X2_sky130_fd_sc_hd__fill_8 abstract view
.subckt X2_sky130_fd_sc_hd__fill_8 VGND VPWR VPB VNB
.ends

.subckt X2_sky130_fd_sc_hd__inv_2 VPB VNB VPWR VGND Y A
X0 Y A VPWR VPB sky130_fd_pr__pfet_01v8_hvt ad=0.135 pd=1.27 as=0.26 ps=2.52 w=1 l=0.15 M=2
X1 VGND A Y VNB sky130_fd_pr__nfet_01v8 ad=0.169 pd=1.82 as=0.08775 ps=0.92 w=0.65 l=0.15 M=2
.ends

.subckt X2_sky130_fd_sc_hd__a41o_1 VGND VPWR A3 A4 A2 X B1 A1 VPB VNB
X0 a_465_47# A2 a_381_47# VNB sky130_fd_pr__nfet_01v8 ad=0.10725 pd=0.98 as=0.08775 ps=0.92 w=0.65 l=0.15
X1 VGND A4 a_561_47# VNB sky130_fd_pr__nfet_01v8 ad=0.169 pd=1.82 as=0.10725 ps=0.98 w=0.65 l=0.15
X2 VPWR A3 a_297_297# VPB sky130_fd_pr__pfet_01v8_hvt ad=0.165 pd=1.33 as=0.165 ps=1.33 w=1 l=0.15
X3 a_297_297# A2 VPWR VPB sky130_fd_pr__pfet_01v8_hvt ad=0.165 pd=1.33 as=0.135 ps=1.27 w=1 l=0.15
X4 a_297_297# A4 VPWR VPB sky130_fd_pr__pfet_01v8_hvt ad=0.26 pd=2.52 as=0.165 ps=1.33 w=1 l=0.15
X5 VPWR A1 a_297_297# VPB sky130_fd_pr__pfet_01v8_hvt ad=0.135 pd=1.27 as=0.135 ps=1.27 w=1 l=0.15
X6 a_381_47# A1 a_79_21# VNB sky130_fd_pr__nfet_01v8 ad=0.08775 pd=0.92 as=0.183625 ps=1.215 w=0.65 l=0.15
X7 a_297_297# B1 a_79_21# VPB sky130_fd_pr__pfet_01v8_hvt ad=0.135 pd=1.27 as=0.26 ps=2.52 w=1 l=0.15
X8 VPWR a_79_21# X VPB sky130_fd_pr__pfet_01v8_hvt ad=0.26 pd=2.52 as=0.26 ps=2.52 w=1 l=0.15
X9 a_79_21# B1 VGND VNB sky130_fd_pr__nfet_01v8 ad=0.183625 pd=1.215 as=0.160875 ps=1.145 w=0.65 l=0.15
X10 VGND a_79_21# X VNB sky130_fd_pr__nfet_01v8 ad=0.160875 pd=1.145 as=0.169 ps=1.82 w=0.65 l=0.15
X11 a_561_47# A3 a_465_47# VNB sky130_fd_pr__nfet_01v8 ad=0.10725 pd=0.98 as=0.10725 ps=0.98 w=0.65 l=0.15
.ends

.subckt X2_sky130_fd_sc_hd__nand2b_2 VNB VPB VGND VPWR A_N Y B
X0 Y B VPWR VPB sky130_fd_pr__pfet_01v8_hvt ad=0.135 pd=1.27 as=0.335 ps=1.67 w=1 l=0.15 M=2
X1 VGND A_N a_27_93# VNB sky130_fd_pr__nfet_01v8 ad=0.194 pd=1.95 as=0.1092 ps=1.36 w=0.42 l=0.15
X2 VGND B a_229_47# VNB sky130_fd_pr__nfet_01v8 ad=0.08775 pd=0.92 as=0.08775 ps=0.92 w=0.65 l=0.15 M=2
X3 Y a_27_93# a_229_47# VNB sky130_fd_pr__nfet_01v8 ad=0.08775 pd=0.92 as=0.169 ps=1.82 w=0.65 l=0.15 M=2
X4 Y a_27_93# VPWR VPB sky130_fd_pr__pfet_01v8_hvt ad=0.165 pd=1.33 as=0.1468 ps=1.34 w=1 l=0.15 M=2
X5 VPWR A_N a_27_93# VPB sky130_fd_pr__pfet_01v8_hvt ad=0.1468 pd=1.34 as=0.1092 ps=1.36 w=0.42 l=0.15
.ends

.subckt X2_sky130_fd_sc_hd__mux2_1 VGND VPWR VPB VNB X A1 S A0
X0 VPWR a_505_21# a_535_374# VPB sky130_fd_pr__pfet_01v8_hvt ad=0.0693 pd=0.75 as=0.0441 ps=0.63 w=0.42 l=0.15
X1 a_505_21# S VPWR VPB sky130_fd_pr__pfet_01v8_hvt ad=0.1176 pd=1.4 as=0.0693 ps=0.75 w=0.42 l=0.15
X2 a_218_374# S VPWR VPB sky130_fd_pr__pfet_01v8_hvt ad=0.07665 pd=0.785 as=0.15835 ps=1.395 w=0.42 l=0.15
X3 VGND a_505_21# a_439_47# VNB sky130_fd_pr__nfet_01v8 ad=0.1449 pd=1.11 as=0.0693 ps=0.75 w=0.42 l=0.15
X4 a_76_199# A0 a_218_374# VPB sky130_fd_pr__pfet_01v8_hvt ad=0.1932 pd=1.34 as=0.07665 ps=0.785 w=0.42 l=0.15
X5 a_505_21# S VGND VNB sky130_fd_pr__nfet_01v8 ad=0.1092 pd=1.36 as=0.1449 ps=1.11 w=0.42 l=0.15
X6 a_439_47# A0 a_76_199# VNB sky130_fd_pr__nfet_01v8 ad=0.0693 pd=0.75 as=0.09975 ps=0.895 w=0.42 l=0.15
X7 a_535_374# A1 a_76_199# VPB sky130_fd_pr__pfet_01v8_hvt ad=0.0441 pd=0.63 as=0.1932 ps=1.34 w=0.42 l=0.15
X8 a_76_199# A1 a_218_47# VNB sky130_fd_pr__nfet_01v8 ad=0.09975 pd=0.895 as=0.0693 ps=0.75 w=0.42 l=0.15
X9 a_218_47# S VGND VNB sky130_fd_pr__nfet_01v8 ad=0.0693 pd=0.75 as=0.11285 ps=1.045 w=0.42 l=0.15
X10 VPWR a_76_199# X VPB sky130_fd_pr__pfet_01v8_hvt ad=0.15835 pd=1.395 as=0.26 ps=2.52 w=1 l=0.15
X11 VGND a_76_199# X VNB sky130_fd_pr__nfet_01v8 ad=0.11285 pd=1.045 as=0.169 ps=1.82 w=0.65 l=0.15
.ends

* Black-box entry subcircuit for X2_sky130_fd_sc_hd__tapvpwrvgnd_1 abstract view
.subckt X2_sky130_fd_sc_hd__tapvpwrvgnd_1 VPWR VGND
.ends

.subckt X2_sky130_fd_sc_hd__o211a_1 VNB VPB VGND VPWR X A1 A2 B1 C1
X0 VGND A1 a_215_47# VNB sky130_fd_pr__nfet_01v8 ad=0.105625 pd=0.975 as=0.169 ps=1.82 w=0.65 l=0.15
X1 a_510_47# B1 a_215_47# VNB sky130_fd_pr__nfet_01v8 ad=0.11375 pd=1 as=0.143 ps=1.09 w=0.65 l=0.15
X2 a_79_21# C1 VPWR VPB sky130_fd_pr__pfet_01v8_hvt ad=0.3 pd=2.6 as=0.175 ps=1.35 w=1 l=0.15
X3 VPWR B1 a_79_21# VPB sky130_fd_pr__pfet_01v8_hvt ad=0.175 pd=1.35 as=0.22 ps=1.44 w=1 l=0.15
X4 a_79_21# A2 a_297_297# VPB sky130_fd_pr__pfet_01v8_hvt ad=0.22 pd=1.44 as=0.1625 ps=1.325 w=1 l=0.15
X5 a_297_297# A1 VPWR VPB sky130_fd_pr__pfet_01v8_hvt ad=0.1625 pd=1.325 as=0.26 ps=2.52 w=1 l=0.15
X6 a_79_21# C1 a_510_47# VNB sky130_fd_pr__nfet_01v8 ad=0.195 pd=1.9 as=0.11375 ps=1 w=0.65 l=0.15
X7 VPWR a_79_21# X VPB sky130_fd_pr__pfet_01v8_hvt ad=0.26 pd=2.52 as=0.26 ps=2.52 w=1 l=0.15
X8 VGND a_79_21# X VNB sky130_fd_pr__nfet_01v8 ad=0.169 pd=1.82 as=0.169 ps=1.82 w=0.65 l=0.15
X9 a_215_47# A2 VGND VNB sky130_fd_pr__nfet_01v8 ad=0.143 pd=1.09 as=0.105625 ps=0.975 w=0.65 l=0.15
.ends

.subckt X2_sky130_fd_sc_hd__or4_1 VPWR VGND VPB VNB B D C A X
X0 a_27_297# B VGND VNB sky130_fd_pr__nfet_01v8 ad=0.0567 pd=0.69 as=0.0567 ps=0.69 w=0.42 l=0.15
X1 a_27_297# D VGND VNB sky130_fd_pr__nfet_01v8 ad=0.0693 pd=0.75 as=0.1092 ps=1.36 w=0.42 l=0.15
X2 a_277_297# B a_205_297# VPB sky130_fd_pr__pfet_01v8_hvt ad=0.0693 pd=0.75 as=0.0441 ps=0.63 w=0.42 l=0.15
X3 VPWR A a_277_297# VPB sky130_fd_pr__pfet_01v8_hvt ad=0.14825 pd=1.34 as=0.0693 ps=0.75 w=0.42 l=0.15
X4 X a_27_297# VGND VNB sky130_fd_pr__nfet_01v8 ad=0.1755 pd=1.84 as=0.101875 ps=0.99 w=0.65 l=0.15
X5 a_205_297# C a_109_297# VPB sky130_fd_pr__pfet_01v8_hvt ad=0.0441 pd=0.63 as=0.0693 ps=0.75 w=0.42 l=0.15
X6 X a_27_297# VPWR VPB sky130_fd_pr__pfet_01v8_hvt ad=0.27 pd=2.54 as=0.14825 ps=1.34 w=1 l=0.15
X7 VGND C a_27_297# VNB sky130_fd_pr__nfet_01v8 ad=0.0567 pd=0.69 as=0.0693 ps=0.75 w=0.42 l=0.15
X8 a_109_297# D a_27_297# VPB sky130_fd_pr__pfet_01v8_hvt ad=0.0693 pd=0.75 as=0.1092 ps=1.36 w=0.42 l=0.15
X9 VGND A a_27_297# VNB sky130_fd_pr__nfet_01v8 ad=0.101875 pd=0.99 as=0.0567 ps=0.69 w=0.42 l=0.15
.ends

.subckt X2_sky130_fd_sc_hd__a221o_1 VPWR VGND VPB VNB A1 A2 X B1 B2 C1
X0 a_465_47# A1 a_27_47# VNB sky130_fd_pr__nfet_01v8 ad=0.10725 pd=0.98 as=0.169 ps=1.82 w=0.65 l=0.15
X1 X a_27_47# VPWR VPB sky130_fd_pr__pfet_01v8_hvt ad=0.26 pd=2.52 as=0.1575 ps=1.315 w=1 l=0.15
X2 a_109_297# B1 a_193_297# VPB sky130_fd_pr__pfet_01v8_hvt ad=0.26 pd=2.52 as=0.135 ps=1.27 w=1 l=0.15
X3 a_193_297# B2 a_109_297# VPB sky130_fd_pr__pfet_01v8_hvt ad=0.135 pd=1.27 as=0.135 ps=1.27 w=1 l=0.15
X4 X a_27_47# VGND VNB sky130_fd_pr__nfet_01v8 ad=0.169 pd=1.82 as=0.102375 ps=0.965 w=0.65 l=0.15
X5 a_205_47# B2 VGND VNB sky130_fd_pr__nfet_01v8 ad=0.06825 pd=0.86 as=0.10725 ps=0.98 w=0.65 l=0.15
X6 VPWR A2 a_193_297# VPB sky130_fd_pr__pfet_01v8_hvt ad=0.1575 pd=1.315 as=0.165 ps=1.33 w=1 l=0.15
X7 a_193_297# A1 VPWR VPB sky130_fd_pr__pfet_01v8_hvt ad=0.165 pd=1.33 as=0.26 ps=2.52 w=1 l=0.15
X8 a_27_47# B1 a_205_47# VNB sky130_fd_pr__nfet_01v8 ad=0.169 pd=1.82 as=0.06825 ps=0.86 w=0.65 l=0.15
X9 a_109_297# C1 a_27_47# VPB sky130_fd_pr__pfet_01v8_hvt ad=0.135 pd=1.27 as=0.26 ps=2.52 w=1 l=0.15
X10 VGND C1 a_27_47# VNB sky130_fd_pr__nfet_01v8 ad=0.10725 pd=0.98 as=0.169 ps=1.82 w=0.65 l=0.15
X11 VGND A2 a_465_47# VNB sky130_fd_pr__nfet_01v8 ad=0.102375 pd=0.965 as=0.10725 ps=0.98 w=0.65 l=0.15
.ends

.subckt X2_sky130_fd_sc_hd__dlygate4sd3_1 X A VPB VNB VGND VPWR
X0 VPWR A a_49_47# VPB sky130_fd_pr__pfet_01v8_hvt ad=0.0567 pd=0.69 as=0.1092 ps=1.36 w=0.42 l=0.15
X1 VGND a_285_47# a_391_47# VNB sky130_fd_pr__nfet_01v8 ad=0.097 pd=0.975 as=0.1092 ps=1.36 w=0.42 l=0.5
X2 X a_391_47# VPWR VPB sky130_fd_pr__pfet_01v8_hvt ad=0.26 pd=2.52 as=0.14075 ps=1.325 w=1 l=0.15
X3 VGND A a_49_47# VNB sky130_fd_pr__nfet_01v8 ad=0.0567 pd=0.69 as=0.1092 ps=1.36 w=0.42 l=0.15
X4 VPWR a_285_47# a_391_47# VPB sky130_fd_pr__pfet_01v8_hvt ad=0.14075 pd=1.325 as=0.1092 ps=1.36 w=0.42 l=0.5
X5 a_285_47# a_49_47# VGND VNB sky130_fd_pr__nfet_01v8 ad=0.1092 pd=1.36 as=0.0567 ps=0.69 w=0.42 l=0.5
X6 a_285_47# a_49_47# VPWR VPB sky130_fd_pr__pfet_01v8_hvt ad=0.1092 pd=1.36 as=0.0567 ps=0.69 w=0.42 l=0.5
X7 X a_391_47# VGND VNB sky130_fd_pr__nfet_01v8 ad=0.169 pd=1.82 as=0.097 ps=0.975 w=0.65 l=0.15
.ends

.subckt X2_sky130_fd_sc_hd__dfstp_1 VPB VNB VPWR VGND Q SET_B D CLK
X0 VGND a_652_21# a_586_47# VNB sky130_fd_pr__nfet_01v8 ad=0.0882 pd=0.84 as=0.06705 ps=0.75 w=0.42 l=0.15
X1 a_956_413# a_476_47# VPWR VPB sky130_fd_pr__pfet_01v8_hvt ad=0.0483 pd=0.65 as=0.0567 ps=0.69 w=0.42 l=0.15
X2 VPWR a_476_47# a_652_21# VPB sky130_fd_pr__pfet_01v8_hvt ad=0.0567 pd=0.69 as=0.0567 ps=0.69 w=0.42 l=0.15
X3 VPWR CLK a_27_47# VPB sky130_fd_pr__pfet_01v8_hvt ad=0.0864 pd=0.91 as=0.1664 ps=1.8 w=0.64 l=0.15
X4 a_586_47# a_193_47# a_476_47# VNB sky130_fd_pr__special_nfet_01v8 ad=0.06705 pd=0.75 as=0.072 ps=0.76 w=0.36 l=0.15
X5 a_1056_47# a_476_47# VGND VNB sky130_fd_pr__nfet_01v8 ad=0.0441 pd=0.63 as=0.1092 ps=1.36 w=0.42 l=0.15
X6 a_476_47# a_27_47# a_381_47# VNB sky130_fd_pr__special_nfet_01v8 ad=0.072 pd=0.76 as=0.0935 ps=0.965 w=0.36 l=0.15
X7 a_381_47# D VPWR VPB sky130_fd_pr__pfet_01v8_hvt ad=0.12495 pd=1.175 as=0.2184 ps=2.2 w=0.84 l=0.15
X8 a_652_21# SET_B VPWR VPB sky130_fd_pr__pfet_01v8_hvt ad=0.0567 pd=0.69 as=0.0798 ps=0.8 w=0.42 l=0.15
X9 a_1224_47# a_27_47# a_1032_413# VNB sky130_fd_pr__nfet_01v8 ad=0.0441 pd=0.63 as=0.0693 ps=0.75 w=0.42 l=0.15
X10 a_562_413# a_27_47# a_476_47# VPB sky130_fd_pr__pfet_01v8_hvt ad=0.0945 pd=0.87 as=0.0567 ps=0.69 w=0.42 l=0.15
X11 VGND a_1032_413# a_1602_47# VNB sky130_fd_pr__nfet_01v8 ad=0.097 pd=0.975 as=0.1092 ps=1.36 w=0.42 l=0.15
X12 VPWR a_1182_261# a_1140_413# VPB sky130_fd_pr__pfet_01v8_hvt ad=0.1092 pd=1.36 as=0.0441 ps=0.63 w=0.42 l=0.15
X13 Q a_1602_47# VPWR VPB sky130_fd_pr__pfet_01v8_hvt ad=0.26 pd=2.52 as=0.149 ps=1.325 w=1 l=0.15
X14 a_1032_413# a_193_47# a_1056_47# VNB sky130_fd_pr__nfet_01v8 ad=0.0693 pd=0.75 as=0.0441 ps=0.63 w=0.42 l=0.15
X15 a_476_47# a_193_47# a_381_47# VPB sky130_fd_pr__pfet_01v8_hvt ad=0.0567 pd=0.69 as=0.12495 ps=1.175 w=0.42 l=0.15
X16 a_1296_47# a_1182_261# a_1224_47# VNB sky130_fd_pr__nfet_01v8 ad=0.0483 pd=0.65 as=0.0441 ps=0.63 w=0.42 l=0.15
X17 a_193_47# a_27_47# VGND VNB sky130_fd_pr__nfet_01v8 ad=0.1092 pd=1.36 as=0.0567 ps=0.69 w=0.42 l=0.15
X18 VPWR a_652_21# a_562_413# VPB sky130_fd_pr__pfet_01v8_hvt ad=0.0798 pd=0.8 as=0.0945 ps=0.87 w=0.42 l=0.15
X19 VPWR SET_B a_1032_413# VPB sky130_fd_pr__pfet_01v8_hvt ad=0.12285 pd=1.17 as=0.1092 ps=1.36 w=0.42 l=0.15
X20 a_1032_413# a_27_47# a_956_413# VPB sky130_fd_pr__pfet_01v8_hvt ad=0.0819 pd=0.81 as=0.0483 ps=0.65 w=0.42 l=0.15
X21 a_1182_261# a_1032_413# VPWR VPB sky130_fd_pr__pfet_01v8_hvt ad=0.2184 pd=2.2 as=0.12285 ps=1.17 w=0.84 l=0.15
X22 Q a_1602_47# VGND VNB sky130_fd_pr__nfet_01v8 ad=0.169 pd=1.82 as=0.097 ps=0.975 w=0.65 l=0.15
X23 a_193_47# a_27_47# VPWR VPB sky130_fd_pr__pfet_01v8_hvt ad=0.1664 pd=1.8 as=0.0864 ps=0.91 w=0.64 l=0.15
X24 a_1140_413# a_193_47# a_1032_413# VPB sky130_fd_pr__pfet_01v8_hvt ad=0.0441 pd=0.63 as=0.0819 ps=0.81 w=0.42 l=0.15
X25 VPWR a_1032_413# a_1602_47# VPB sky130_fd_pr__pfet_01v8_hvt ad=0.149 pd=1.325 as=0.1664 ps=1.8 w=0.64 l=0.15
X26 a_796_47# SET_B VGND VNB sky130_fd_pr__nfet_01v8 ad=0.0441 pd=0.63 as=0.0882 ps=0.84 w=0.42 l=0.15
X27 a_381_47# D VGND VNB sky130_fd_pr__nfet_01v8 ad=0.0935 pd=0.965 as=0.1664 ps=1.8 w=0.64 l=0.15
X28 a_1182_261# a_1032_413# VGND VNB sky130_fd_pr__nfet_01v8 ad=0.1404 pd=1.6 as=0.1137 ps=1.01 w=0.54 l=0.15
X29 a_652_21# a_476_47# a_796_47# VNB sky130_fd_pr__nfet_01v8 ad=0.1092 pd=1.36 as=0.0441 ps=0.63 w=0.42 l=0.15
X30 VGND CLK a_27_47# VNB sky130_fd_pr__nfet_01v8 ad=0.0567 pd=0.69 as=0.1092 ps=1.36 w=0.42 l=0.15
X31 VGND SET_B a_1296_47# VNB sky130_fd_pr__nfet_01v8 ad=0.1137 pd=1.01 as=0.0483 ps=0.65 w=0.42 l=0.15
.ends

.subckt X2_sky130_fd_sc_hd__clkbuf_16 VNB VPB VGND VPWR A X
X0 VPWR A a_110_47# VPB sky130_fd_pr__pfet_01v8_hvt ad=0.14 pd=1.28 as=0.14 ps=1.28 w=1 l=0.15 M=4
X1 VPWR a_110_47# X VPB sky130_fd_pr__pfet_01v8_hvt ad=0.14 pd=1.28 as=0.14 ps=1.28 w=1 l=0.15 M=16
X2 a_110_47# A VGND VNB sky130_fd_pr__nfet_01v8 ad=0.0588 pd=0.7 as=0.0588 ps=0.7 w=0.42 l=0.15 M=4
X3 VGND a_110_47# X VNB sky130_fd_pr__nfet_01v8 ad=0.0588 pd=0.7 as=0.0588 ps=0.7 w=0.42 l=0.15 M=16
.ends

.subckt X2_sky130_fd_sc_hd__buf_2 VPWR VGND X A VPB VNB
X0 VPWR a_27_47# X VPB sky130_fd_pr__pfet_01v8_hvt ad=0.265 pd=2.53 as=0.135 ps=1.27 w=1 l=0.15 M=2
X1 VPWR A a_27_47# VPB sky130_fd_pr__pfet_01v8_hvt ad=0.149 pd=1.325 as=0.1664 ps=1.8 w=0.64 l=0.15
X2 X a_27_47# VGND VNB sky130_fd_pr__nfet_01v8 ad=0.08775 pd=0.92 as=0.097 ps=0.975 w=0.65 l=0.15 M=2
X3 VGND A a_27_47# VNB sky130_fd_pr__nfet_01v8 ad=0.097 pd=0.975 as=0.1092 ps=1.36 w=0.42 l=0.15
.ends

.subckt X2_sky130_fd_sc_hd__and2b_1 X A_N B VGND VPWR VPB VNB
X0 VPWR B a_207_413# VPB sky130_fd_pr__pfet_01v8_hvt ad=0.2279 pd=1.74 as=0.0609 ps=0.71 w=0.42 l=0.15
X1 X a_207_413# VPWR VPB sky130_fd_pr__pfet_01v8_hvt ad=0.26 pd=2.52 as=0.2279 ps=1.74 w=1 l=0.15
X2 a_297_47# a_27_413# a_207_413# VNB sky130_fd_pr__nfet_01v8 ad=0.0504 pd=0.66 as=0.1092 ps=1.36 w=0.42 l=0.15
X3 X a_207_413# VGND VNB sky130_fd_pr__nfet_01v8 ad=0.169 pd=1.82 as=0.1013 ps=0.99 w=0.65 l=0.15
X4 a_207_413# a_27_413# VPWR VPB sky130_fd_pr__pfet_01v8_hvt ad=0.0609 pd=0.71 as=0.0714 ps=0.76 w=0.42 l=0.15
X5 VPWR A_N a_27_413# VPB sky130_fd_pr__pfet_01v8_hvt ad=0.0714 pd=0.76 as=0.1092 ps=1.36 w=0.42 l=0.15
X6 VGND B a_297_47# VNB sky130_fd_pr__nfet_01v8 ad=0.1013 pd=0.99 as=0.0504 ps=0.66 w=0.42 l=0.15
X7 a_27_413# A_N VGND VNB sky130_fd_pr__nfet_01v8 ad=0.1092 pd=1.36 as=0.1092 ps=1.36 w=0.42 l=0.15
.ends

.subckt X2_sky130_fd_sc_hd__xnor2_1 VGND VPWR B Y A VPB VNB
X0 a_377_297# A VPWR VPB sky130_fd_pr__pfet_01v8_hvt ad=0.105 pd=1.21 as=0.365 ps=1.73 w=1 l=0.15
X1 a_47_47# B VPWR VPB sky130_fd_pr__pfet_01v8_hvt ad=0.135 pd=1.27 as=0.3 ps=2.6 w=1 l=0.15
X2 a_129_47# B a_47_47# VNB sky130_fd_pr__nfet_01v8 ad=0.06825 pd=0.86 as=0.169 ps=1.82 w=0.65 l=0.15
X3 a_285_47# B VGND VNB sky130_fd_pr__nfet_01v8 ad=0.08775 pd=0.92 as=0.169 ps=1.82 w=0.65 l=0.15
X4 Y a_47_47# a_285_47# VNB sky130_fd_pr__nfet_01v8 ad=0.195 pd=1.9 as=0.08775 ps=0.92 w=0.65 l=0.15
X5 VGND A a_129_47# VNB sky130_fd_pr__nfet_01v8 ad=0.08775 pd=0.92 as=0.06825 ps=0.86 w=0.65 l=0.15
X6 VPWR A a_47_47# VPB sky130_fd_pr__pfet_01v8_hvt ad=0.365 pd=1.73 as=0.135 ps=1.27 w=1 l=0.15
X7 VPWR a_47_47# Y VPB sky130_fd_pr__pfet_01v8_hvt ad=0.36 pd=2.72 as=0.165 ps=1.33 w=1 l=0.15
X8 Y B a_377_297# VPB sky130_fd_pr__pfet_01v8_hvt ad=0.165 pd=1.33 as=0.105 ps=1.21 w=1 l=0.15
X9 a_285_47# A VGND VNB sky130_fd_pr__nfet_01v8 ad=0.169 pd=1.82 as=0.08775 ps=0.92 w=0.65 l=0.15
.ends

.subckt X2_sky130_fd_sc_hd__decap_3 VPWR VGND VPB VNB
X0 VPWR VGND VPWR VPB sky130_fd_pr__pfet_01v8_hvt ad=0.2262 pd=2.26 as=0 ps=0 w=0.87 l=0.59
X1 VGND VPWR VGND VNB sky130_fd_pr__nfet_01v8 ad=0.143 pd=1.62 as=0 ps=0 w=0.55 l=0.59
.ends

.subckt X2_sky130_fd_sc_hd__o22a_1 VPB VNB VGND VPWR B2 A2 A1 B1 X
X0 a_78_199# B1 a_215_47# VNB sky130_fd_pr__nfet_01v8 ad=0.08775 pd=0.92 as=0.169 ps=1.82 w=0.65 l=0.15
X1 VPWR A1 a_493_297# VPB sky130_fd_pr__pfet_01v8_hvt ad=0.26 pd=2.52 as=0.105 ps=1.21 w=1 l=0.15
X2 a_493_297# A2 a_78_199# VPB sky130_fd_pr__pfet_01v8_hvt ad=0.105 pd=1.21 as=0.235 ps=1.47 w=1 l=0.15
X3 VPWR a_78_199# X VPB sky130_fd_pr__pfet_01v8_hvt ad=0.3725 pd=1.745 as=0.28 ps=2.56 w=1 l=0.15
X4 VGND A2 a_215_47# VNB sky130_fd_pr__nfet_01v8 ad=0.08775 pd=0.92 as=0.11375 ps=1 w=0.65 l=0.15
X5 a_78_199# B2 a_292_297# VPB sky130_fd_pr__pfet_01v8_hvt ad=0.235 pd=1.47 as=0.1175 ps=1.235 w=1 l=0.15
X6 a_215_47# A1 VGND VNB sky130_fd_pr__nfet_01v8 ad=0.169 pd=1.82 as=0.08775 ps=0.92 w=0.65 l=0.15
X7 a_215_47# B2 a_78_199# VNB sky130_fd_pr__nfet_01v8 ad=0.11375 pd=1 as=0.08775 ps=0.92 w=0.65 l=0.15
X8 a_292_297# B1 VPWR VPB sky130_fd_pr__pfet_01v8_hvt ad=0.1175 pd=1.235 as=0.3725 ps=1.745 w=1 l=0.15
X9 VGND a_78_199# X VNB sky130_fd_pr__nfet_01v8 ad=0.169 pd=1.82 as=0.169 ps=1.82 w=0.65 l=0.15
.ends

.subckt X2_sky130_fd_sc_hd__dfrtp_1 VGND VPWR VPB VNB CLK D RESET_B Q
X0 a_805_47# a_761_289# a_639_47# VNB sky130_fd_pr__nfet_01v8 ad=0.0441 pd=0.63 as=0.1401 ps=1.1 w=0.42 l=0.15
X1 a_1217_47# a_27_47# a_1108_47# VNB sky130_fd_pr__special_nfet_01v8 ad=0.0669 pd=0.75 as=0.0711 ps=0.755 w=0.36 l=0.15
X2 a_1283_21# a_1108_47# a_1462_47# VNB sky130_fd_pr__nfet_01v8 ad=0.1092 pd=1.36 as=0.06405 ps=0.725 w=0.42 l=0.15
X3 a_651_413# a_27_47# a_543_47# VPB sky130_fd_pr__pfet_01v8_hvt ad=0.1155 pd=0.97 as=0.07245 ps=0.765 w=0.42 l=0.15
X4 a_1108_47# a_193_47# a_761_289# VNB sky130_fd_pr__special_nfet_01v8 ad=0.0711 pd=0.755 as=0.0999 ps=0.985 w=0.36 l=0.15
X5 VGND RESET_B a_805_47# VNB sky130_fd_pr__nfet_01v8 ad=0.1346 pd=1.15 as=0.0441 ps=0.63 w=0.42 l=0.15
X6 Q a_1283_21# VPWR VPB sky130_fd_pr__pfet_01v8_hvt ad=0.26 pd=2.52 as=0.3012 ps=2.66 w=1 l=0.15
X7 VPWR CLK a_27_47# VPB sky130_fd_pr__pfet_01v8_hvt ad=0.0864 pd=0.91 as=0.1664 ps=1.8 w=0.64 l=0.15
X8 a_448_47# D VPWR VPB sky130_fd_pr__pfet_01v8_hvt ad=0.0651 pd=0.73 as=0.1092 ps=1.36 w=0.42 l=0.15
X9 a_761_289# a_543_47# VGND VNB sky130_fd_pr__nfet_01v8 ad=0.0999 pd=0.985 as=0.1346 ps=1.15 w=0.64 l=0.15
X10 a_193_47# a_27_47# VGND VNB sky130_fd_pr__nfet_01v8 ad=0.1092 pd=1.36 as=0.0567 ps=0.69 w=0.42 l=0.15
X11 a_1108_47# a_27_47# a_761_289# VPB sky130_fd_pr__pfet_01v8_hvt ad=0.0588 pd=0.7 as=0.12915 ps=1.185 w=0.42 l=0.15
X12 a_1462_47# RESET_B VGND VNB sky130_fd_pr__nfet_01v8 ad=0.06405 pd=0.725 as=0.12495 ps=1.015 w=0.42 l=0.15
X13 a_543_47# a_27_47# a_448_47# VNB sky130_fd_pr__special_nfet_01v8 ad=0.0594 pd=0.69 as=0.066 ps=0.745 w=0.36 l=0.15
X14 a_543_47# a_193_47# a_448_47# VPB sky130_fd_pr__pfet_01v8_hvt ad=0.07245 pd=0.765 as=0.0651 ps=0.73 w=0.42 l=0.15
X15 a_448_47# D VGND VNB sky130_fd_pr__nfet_01v8 ad=0.066 pd=0.745 as=0.2205 ps=1.89 w=0.42 l=0.15
X16 VPWR a_1283_21# a_1270_413# VPB sky130_fd_pr__pfet_01v8_hvt ad=0.0819 pd=0.81 as=0.0567 ps=0.69 w=0.42 l=0.15
X17 VPWR a_1108_47# a_1283_21# VPB sky130_fd_pr__pfet_01v8_hvt ad=0.1134 pd=1.38 as=0.0567 ps=0.69 w=0.42 l=0.15
X18 a_1270_413# a_193_47# a_1108_47# VPB sky130_fd_pr__pfet_01v8_hvt ad=0.0567 pd=0.69 as=0.0588 ps=0.7 w=0.42 l=0.15
X19 a_193_47# a_27_47# VPWR VPB sky130_fd_pr__pfet_01v8_hvt ad=0.1664 pd=1.8 as=0.0864 ps=0.91 w=0.64 l=0.15
X20 a_1283_21# RESET_B VPWR VPB sky130_fd_pr__pfet_01v8_hvt ad=0.0567 pd=0.69 as=0.0819 ps=0.81 w=0.42 l=0.15
X21 VPWR a_761_289# a_651_413# VPB sky130_fd_pr__pfet_01v8_hvt ad=0.07035 pd=0.755 as=0.1155 ps=0.97 w=0.42 l=0.15
X22 Q a_1283_21# VGND VNB sky130_fd_pr__nfet_01v8 ad=0.169 pd=1.82 as=0.2087 ps=2.02 w=0.65 l=0.15
X23 a_639_47# a_193_47# a_543_47# VNB sky130_fd_pr__special_nfet_01v8 ad=0.1401 pd=1.1 as=0.0594 ps=0.69 w=0.36 l=0.15
X24 VGND a_1283_21# a_1217_47# VNB sky130_fd_pr__nfet_01v8 ad=0.12495 pd=1.015 as=0.0669 ps=0.75 w=0.42 l=0.15
X25 a_651_413# RESET_B VPWR VPB sky130_fd_pr__pfet_01v8_hvt ad=0.1092 pd=1.36 as=0.07035 ps=0.755 w=0.42 l=0.15
X26 VGND CLK a_27_47# VNB sky130_fd_pr__nfet_01v8 ad=0.0567 pd=0.69 as=0.1092 ps=1.36 w=0.42 l=0.15
X27 a_761_289# a_543_47# VPWR VPB sky130_fd_pr__pfet_01v8_hvt ad=0.12915 pd=1.185 as=0.2184 ps=2.2 w=0.84 l=0.15
.ends

.subckt X2_sky130_fd_sc_hd__and3_1 VGND VPWR X B A C VPB VNB
X0 VPWR A a_27_47# VPB sky130_fd_pr__pfet_01v8_hvt ad=0.0567 pd=0.69 as=0.1092 ps=1.36 w=0.42 l=0.15
X1 VPWR C a_27_47# VPB sky130_fd_pr__pfet_01v8_hvt ad=0.142225 pd=1.335 as=0.06615 ps=0.735 w=0.42 l=0.15
X2 a_181_47# B a_109_47# VNB sky130_fd_pr__nfet_01v8 ad=0.0441 pd=0.63 as=0.0441 ps=0.63 w=0.42 l=0.15
X3 VGND C a_181_47# VNB sky130_fd_pr__nfet_01v8 ad=0.13165 pd=1.14 as=0.0441 ps=0.63 w=0.42 l=0.15
X4 a_27_47# B VPWR VPB sky130_fd_pr__pfet_01v8_hvt ad=0.06615 pd=0.735 as=0.0567 ps=0.69 w=0.42 l=0.15
X5 X a_27_47# VPWR VPB sky130_fd_pr__pfet_01v8_hvt ad=0.26 pd=2.52 as=0.142225 ps=1.335 w=1 l=0.15
X6 X a_27_47# VGND VNB sky130_fd_pr__nfet_01v8 ad=0.169 pd=1.82 as=0.13165 ps=1.14 w=0.65 l=0.15
X7 a_109_47# A a_27_47# VNB sky130_fd_pr__nfet_01v8 ad=0.0441 pd=0.63 as=0.1092 ps=1.36 w=0.42 l=0.15
.ends

.subckt X2_sky130_fd_sc_hd__xnor2_2 VGND VPWR Y A B VPB VNB
X0 a_27_297# B VPWR VPB sky130_fd_pr__pfet_01v8_hvt ad=0.135 pd=1.27 as=0.135 ps=1.27 w=1 l=0.15 M=2
X1 a_560_47# A VGND VNB sky130_fd_pr__nfet_01v8 ad=0.08775 pd=0.92 as=0.182 ps=1.86 w=0.65 l=0.15 M=2
X2 VGND B a_560_47# VNB sky130_fd_pr__nfet_01v8 ad=0.169 pd=1.82 as=0.099125 ps=0.955 w=0.65 l=0.15 M=2
X3 Y B a_474_297# VPB sky130_fd_pr__pfet_01v8_hvt ad=0.1525 pd=1.305 as=0.135 ps=1.27 w=1 l=0.15 M=2
X4 VGND A a_27_47# VNB sky130_fd_pr__nfet_01v8 ad=0.08775 pd=0.92 as=0.08775 ps=0.92 w=0.65 l=0.15 M=2
X5 Y a_27_297# a_560_47# VNB sky130_fd_pr__nfet_01v8 ad=0.169 pd=1.82 as=0.08775 ps=0.92 w=0.65 l=0.15 M=2
X6 a_27_47# B a_27_297# VNB sky130_fd_pr__nfet_01v8 ad=0.08775 pd=0.92 as=0.08775 ps=0.92 w=0.65 l=0.15 M=2
X7 a_474_297# A VPWR VPB sky130_fd_pr__pfet_01v8_hvt ad=0.135 pd=1.27 as=0.135 ps=1.27 w=1 l=0.15 M=2
X8 Y a_27_297# VPWR VPB sky130_fd_pr__pfet_01v8_hvt ad=0.135 pd=1.27 as=0.26 ps=2.52 w=1 l=0.15 M=2
X9 a_27_297# A VPWR VPB sky130_fd_pr__pfet_01v8_hvt ad=0.28 pd=2.56 as=0.135 ps=1.27 w=1 l=0.15 M=2
.ends

.subckt X2_sky130_fd_sc_hd__clkbuf_1 VGND VPWR X A VPB VNB
X0 VPWR a_75_212# X VPB sky130_fd_pr__pfet_01v8_hvt ad=0.11455 pd=1.08 as=0.2054 ps=2.1 w=0.79 l=0.15
X1 a_75_212# A VGND VNB sky130_fd_pr__nfet_01v8 ad=0.1352 pd=1.56 as=0.0754 ps=0.81 w=0.52 l=0.15
X2 a_75_212# A VPWR VPB sky130_fd_pr__pfet_01v8_hvt ad=0.2054 pd=2.1 as=0.11455 ps=1.08 w=0.79 l=0.15
X3 VGND a_75_212# X VNB sky130_fd_pr__nfet_01v8 ad=0.0754 pd=0.81 as=0.1352 ps=1.56 w=0.52 l=0.15
.ends

.subckt X2_sky130_fd_sc_hd__a22o_1 VPWR VGND VPB VNB B1 A1 A2 X B2
X0 VPWR A2 a_109_297# VPB sky130_fd_pr__pfet_01v8_hvt ad=0.155 pd=1.31 as=0.16 ps=1.32 w=1 l=0.15
X1 a_27_297# B1 a_109_47# VNB sky130_fd_pr__nfet_01v8 ad=0.169 pd=1.82 as=0.07475 ps=0.88 w=0.65 l=0.15
X2 VGND A2 a_373_47# VNB sky130_fd_pr__nfet_01v8 ad=0.10075 pd=0.96 as=0.11375 ps=1 w=0.65 l=0.15
X3 X a_27_297# VPWR VPB sky130_fd_pr__pfet_01v8_hvt ad=0.26 pd=2.52 as=0.155 ps=1.31 w=1 l=0.15
X4 a_27_297# B1 a_109_297# VPB sky130_fd_pr__pfet_01v8_hvt ad=0.25285 pd=2.52 as=0.135 ps=1.27 w=1 l=0.15
X5 a_109_297# A1 VPWR VPB sky130_fd_pr__pfet_01v8_hvt ad=0.16 pd=1.32 as=0.2529 ps=2.52 w=1 l=0.15
X6 a_373_47# A1 a_27_297# VNB sky130_fd_pr__nfet_01v8 ad=0.11375 pd=1 as=0.169 ps=1.82 w=0.65 l=0.15
X7 X a_27_297# VGND VNB sky130_fd_pr__nfet_01v8 ad=0.169 pd=1.82 as=0.10075 ps=0.96 w=0.65 l=0.15
X8 a_109_297# B2 a_27_297# VPB sky130_fd_pr__pfet_01v8_hvt ad=0.135 pd=1.27 as=0.26 ps=2.52 w=1 l=0.15
X9 a_109_47# B2 VGND VNB sky130_fd_pr__nfet_01v8 ad=0.07475 pd=0.88 as=0.169 ps=1.82 w=0.65 l=0.15
.ends

.subckt X2_sky130_fd_sc_hd__nand2_4 VPB VNB VGND VPWR B Y A
X0 a_27_47# A Y VNB sky130_fd_pr__nfet_01v8 ad=0.08775 pd=0.92 as=0.08775 ps=0.92 w=0.65 l=0.15 M=4
X1 Y A VPWR VPB sky130_fd_pr__pfet_01v8_hvt ad=0.135 pd=1.27 as=0.135 ps=1.27 w=1 l=0.15 M=4
X2 VPWR B Y VPB sky130_fd_pr__pfet_01v8_hvt ad=0.135 pd=1.27 as=0.135 ps=1.27 w=1 l=0.15 M=4
X3 a_27_47# B VGND VNB sky130_fd_pr__nfet_01v8 ad=0.08775 pd=0.92 as=0.08775 ps=0.92 w=0.65 l=0.15 M=4
.ends

.subckt X2_sky130_fd_sc_hd__o21a_1 VPB VNB VGND VPWR A1 A2 B1 X
X0 VPWR A1 a_382_297# VPB sky130_fd_pr__pfet_01v8_hvt ad=0.26 pd=2.52 as=0.1525 ps=1.305 w=1 l=0.15
X1 a_297_47# B1 a_79_21# VNB sky130_fd_pr__nfet_01v8 ad=0.10075 pd=0.96 as=0.169 ps=1.82 w=0.65 l=0.15
X2 a_297_47# A1 VGND VNB sky130_fd_pr__nfet_01v8 ad=0.169 pd=1.82 as=0.08775 ps=0.92 w=0.65 l=0.15
X3 VGND A2 a_297_47# VNB sky130_fd_pr__nfet_01v8 ad=0.08775 pd=0.92 as=0.10075 ps=0.96 w=0.65 l=0.15
X4 VPWR a_79_21# X VPB sky130_fd_pr__pfet_01v8_hvt ad=0.3275 pd=1.655 as=0.28 ps=2.56 w=1 l=0.15
X5 a_79_21# B1 VPWR VPB sky130_fd_pr__pfet_01v8_hvt ad=0.195 pd=1.39 as=0.3275 ps=1.655 w=1 l=0.15
X6 a_382_297# A2 a_79_21# VPB sky130_fd_pr__pfet_01v8_hvt ad=0.1525 pd=1.305 as=0.195 ps=1.39 w=1 l=0.15
X7 VGND a_79_21# X VNB sky130_fd_pr__nfet_01v8 ad=0.169 pd=1.82 as=0.169 ps=1.82 w=0.65 l=0.15
.ends

.subckt X2_sky130_fd_sc_hd__or4b_2 VPWR VGND VPB VNB C D_N X A B
X0 a_176_21# C VGND VNB sky130_fd_pr__nfet_01v8 ad=0.0567 pd=0.69 as=0.0567 ps=0.69 w=0.42 l=0.15
X1 VGND D_N a_27_53# VNB sky130_fd_pr__nfet_01v8 ad=0.10025 pd=0.985 as=0.1092 ps=1.36 w=0.42 l=0.15
X2 VGND a_176_21# X VNB sky130_fd_pr__nfet_01v8 ad=0.10025 pd=0.985 as=0.08775 ps=0.92 w=0.65 l=0.15 M=2
X3 VPWR a_176_21# X VPB sky130_fd_pr__pfet_01v8_hvt ad=0.16835 pd=1.495 as=0.135 ps=1.27 w=1 l=0.15 M=2
X4 a_555_297# C a_483_297# VPB sky130_fd_pr__pfet_01v8_hvt ad=0.0693 pd=0.75 as=0.0441 ps=0.63 w=0.42 l=0.15
X5 a_176_21# a_27_53# a_555_297# VPB sky130_fd_pr__pfet_01v8_hvt ad=0.1092 pd=1.36 as=0.0693 ps=0.75 w=0.42 l=0.15
X6 a_387_297# A VPWR VPB sky130_fd_pr__pfet_01v8_hvt ad=0.0693 pd=0.75 as=0.16835 ps=1.495 w=0.42 l=0.15
X7 a_483_297# B a_387_297# VPB sky130_fd_pr__pfet_01v8_hvt ad=0.0441 pd=0.63 as=0.0693 ps=0.75 w=0.42 l=0.15
X8 VGND B a_176_21# VNB sky130_fd_pr__nfet_01v8 ad=0.0567 pd=0.69 as=0.0693 ps=0.75 w=0.42 l=0.15
X9 VGND a_27_53# a_176_21# VNB sky130_fd_pr__nfet_01v8 ad=0.1092 pd=1.36 as=0.0567 ps=0.69 w=0.42 l=0.15
X10 VPWR D_N a_27_53# VPB sky130_fd_pr__pfet_01v8_hvt ad=0.1693 pd=1.5 as=0.1092 ps=1.36 w=0.42 l=0.15
X11 a_176_21# A VGND VNB sky130_fd_pr__nfet_01v8 ad=0.0693 pd=0.75 as=0.10025 ps=0.985 w=0.42 l=0.15
.ends

.subckt X2_sky130_fd_sc_hd__and4b_4 VNB VPB VGND VPWR A_N X D C B
X0 VPWR a_174_21# X VPB sky130_fd_pr__pfet_01v8_hvt ad=0.3275 pd=1.655 as=0.135 ps=1.27 w=1 l=0.15 M=4
X1 a_815_47# B a_701_47# VNB sky130_fd_pr__nfet_01v8 ad=0.143 pd=1.09 as=0.1365 ps=1.07 w=0.65 l=0.15
X2 VPWR C a_174_21# VPB sky130_fd_pr__pfet_01v8_hvt ad=0.21 pd=1.42 as=0.135 ps=1.27 w=1 l=0.15
X3 a_174_21# a_27_47# a_815_47# VNB sky130_fd_pr__nfet_01v8 ad=0.169 pd=1.82 as=0.143 ps=1.09 w=0.65 l=0.15
X4 VPWR A_N a_27_47# VPB sky130_fd_pr__pfet_01v8_hvt ad=0.14075 pd=1.325 as=0.1092 ps=1.36 w=0.42 l=0.15
X5 a_701_47# C a_617_47# VNB sky130_fd_pr__nfet_01v8 ad=0.1365 pd=1.07 as=0.08775 ps=0.92 w=0.65 l=0.15
X6 a_174_21# D VPWR VPB sky130_fd_pr__pfet_01v8_hvt ad=0.135 pd=1.27 as=0.3275 ps=1.655 w=1 l=0.15
X7 a_174_21# B VPWR VPB sky130_fd_pr__pfet_01v8_hvt ad=0.22 pd=1.44 as=0.21 ps=1.42 w=1 l=0.15
X8 VPWR a_27_47# a_174_21# VPB sky130_fd_pr__pfet_01v8_hvt ad=0.26 pd=2.52 as=0.22 ps=1.44 w=1 l=0.15
X9 X a_174_21# VGND VNB sky130_fd_pr__nfet_01v8 ad=0.08775 pd=0.92 as=0.097 ps=0.975 w=0.65 l=0.15 M=4
X10 a_617_47# D VGND VNB sky130_fd_pr__nfet_01v8 ad=0.08775 pd=0.92 as=0.212875 ps=1.305 w=0.65 l=0.15
X11 VGND A_N a_27_47# VNB sky130_fd_pr__nfet_01v8 ad=0.097 pd=0.975 as=0.1092 ps=1.36 w=0.42 l=0.15
.ends

.subckt X2_sky130_fd_sc_hd__nand3_1 VPB VNB VGND VPWR A B Y C
X0 VPWR B Y VPB sky130_fd_pr__pfet_01v8_hvt ad=0.165 pd=1.33 as=0.135 ps=1.27 w=1 l=0.15
X1 Y A VPWR VPB sky130_fd_pr__pfet_01v8_hvt ad=0.26 pd=2.52 as=0.165 ps=1.33 w=1 l=0.15
X2 a_193_47# B a_109_47# VNB sky130_fd_pr__nfet_01v8 ad=0.10725 pd=0.98 as=0.08775 ps=0.92 w=0.65 l=0.15
X3 Y A a_193_47# VNB sky130_fd_pr__nfet_01v8 ad=0.169 pd=1.82 as=0.10725 ps=0.98 w=0.65 l=0.15
X4 Y C VPWR VPB sky130_fd_pr__pfet_01v8_hvt ad=0.135 pd=1.27 as=0.26 ps=2.52 w=1 l=0.15
X5 a_109_47# C VGND VNB sky130_fd_pr__nfet_01v8 ad=0.08775 pd=0.92 as=0.169 ps=1.82 w=0.65 l=0.15
.ends

.subckt X2_sky130_fd_sc_hd__clkinv_1 VPB VNB VGND VPWR A Y
X0 Y A VPWR VPB sky130_fd_pr__pfet_01v8_hvt ad=0.1134 pd=1.11 as=0.2184 ps=2.2 w=0.84 l=0.15 M=2
X1 VGND A Y VNB sky130_fd_pr__nfet_01v8 ad=0.1197 pd=1.41 as=0.1092 ps=1.36 w=0.42 l=0.15
.ends

.subckt X2_sky130_fd_sc_hd__dfrtp_2 VGND VPWR VPB VNB CLK D RESET_B Q
X0 a_805_47# a_761_289# a_639_47# VNB sky130_fd_pr__nfet_01v8 ad=0.0441 pd=0.63 as=0.1401 ps=1.1 w=0.42 l=0.15
X1 a_1217_47# a_27_47# a_1108_47# VNB sky130_fd_pr__special_nfet_01v8 ad=0.0669 pd=0.75 as=0.0711 ps=0.755 w=0.36 l=0.15
X2 VGND a_1283_21# Q VNB sky130_fd_pr__nfet_01v8 ad=0.169 pd=1.82 as=0.08775 ps=0.92 w=0.65 l=0.15 M=2
X3 a_1283_21# a_1108_47# a_1462_47# VNB sky130_fd_pr__nfet_01v8 ad=0.1092 pd=1.36 as=0.06405 ps=0.725 w=0.42 l=0.15
X4 a_651_413# a_27_47# a_543_47# VPB sky130_fd_pr__pfet_01v8_hvt ad=0.1155 pd=0.97 as=0.07245 ps=0.765 w=0.42 l=0.15
X5 VPWR a_1283_21# Q VPB sky130_fd_pr__pfet_01v8_hvt ad=0.26 pd=2.52 as=0.135 ps=1.27 w=1 l=0.15 M=2
X6 a_1108_47# a_193_47# a_761_289# VNB sky130_fd_pr__special_nfet_01v8 ad=0.0711 pd=0.755 as=0.0999 ps=0.985 w=0.36 l=0.15
X7 VGND RESET_B a_805_47# VNB sky130_fd_pr__nfet_01v8 ad=0.1346 pd=1.15 as=0.0441 ps=0.63 w=0.42 l=0.15
X8 VPWR CLK a_27_47# VPB sky130_fd_pr__pfet_01v8_hvt ad=0.0864 pd=0.91 as=0.1664 ps=1.8 w=0.64 l=0.15
X9 a_448_47# D VPWR VPB sky130_fd_pr__pfet_01v8_hvt ad=0.0651 pd=0.73 as=0.1092 ps=1.36 w=0.42 l=0.15
X10 a_761_289# a_543_47# VGND VNB sky130_fd_pr__nfet_01v8 ad=0.0999 pd=0.985 as=0.1346 ps=1.15 w=0.64 l=0.15
X11 a_193_47# a_27_47# VGND VNB sky130_fd_pr__nfet_01v8 ad=0.1092 pd=1.36 as=0.0567 ps=0.69 w=0.42 l=0.15
X12 a_1108_47# a_27_47# a_761_289# VPB sky130_fd_pr__pfet_01v8_hvt ad=0.0588 pd=0.7 as=0.12915 ps=1.185 w=0.42 l=0.15
X13 a_1462_47# RESET_B VGND VNB sky130_fd_pr__nfet_01v8 ad=0.06405 pd=0.725 as=0.12495 ps=1.015 w=0.42 l=0.15
X14 a_543_47# a_27_47# a_448_47# VNB sky130_fd_pr__special_nfet_01v8 ad=0.0594 pd=0.69 as=0.066 ps=0.745 w=0.36 l=0.15
X15 a_543_47# a_193_47# a_448_47# VPB sky130_fd_pr__pfet_01v8_hvt ad=0.07245 pd=0.765 as=0.0651 ps=0.73 w=0.42 l=0.15
X16 a_448_47# D VGND VNB sky130_fd_pr__nfet_01v8 ad=0.066 pd=0.745 as=0.2205 ps=1.89 w=0.42 l=0.15
X17 VPWR a_1283_21# a_1270_413# VPB sky130_fd_pr__pfet_01v8_hvt ad=0.0819 pd=0.81 as=0.0567 ps=0.69 w=0.42 l=0.15
X18 VPWR a_1108_47# a_1283_21# VPB sky130_fd_pr__pfet_01v8_hvt ad=0.1134 pd=1.38 as=0.0567 ps=0.69 w=0.42 l=0.15
X19 a_1270_413# a_193_47# a_1108_47# VPB sky130_fd_pr__pfet_01v8_hvt ad=0.0567 pd=0.69 as=0.0588 ps=0.7 w=0.42 l=0.15
X20 a_193_47# a_27_47# VPWR VPB sky130_fd_pr__pfet_01v8_hvt ad=0.1664 pd=1.8 as=0.0864 ps=0.91 w=0.64 l=0.15
X21 a_1283_21# RESET_B VPWR VPB sky130_fd_pr__pfet_01v8_hvt ad=0.0567 pd=0.69 as=0.0819 ps=0.81 w=0.42 l=0.15
X22 VPWR a_761_289# a_651_413# VPB sky130_fd_pr__pfet_01v8_hvt ad=0.07035 pd=0.755 as=0.1155 ps=0.97 w=0.42 l=0.15
X23 a_639_47# a_193_47# a_543_47# VNB sky130_fd_pr__special_nfet_01v8 ad=0.1401 pd=1.1 as=0.0594 ps=0.69 w=0.36 l=0.15
X24 VGND a_1283_21# a_1217_47# VNB sky130_fd_pr__nfet_01v8 ad=0.12495 pd=1.015 as=0.0669 ps=0.75 w=0.42 l=0.15
X25 a_651_413# RESET_B VPWR VPB sky130_fd_pr__pfet_01v8_hvt ad=0.1092 pd=1.36 as=0.07035 ps=0.755 w=0.42 l=0.15
X26 VGND CLK a_27_47# VNB sky130_fd_pr__nfet_01v8 ad=0.0567 pd=0.69 as=0.1092 ps=1.36 w=0.42 l=0.15
X27 a_761_289# a_543_47# VPWR VPB sky130_fd_pr__pfet_01v8_hvt ad=0.12915 pd=1.185 as=0.2184 ps=2.2 w=0.84 l=0.15
.ends

.subckt X2_sky130_fd_sc_hd__a21oi_1 VPWR VGND VPB VNB A2 A1 B1 Y
X0 a_199_47# A1 Y VNB sky130_fd_pr__nfet_01v8 ad=0.095875 pd=0.945 as=0.091 ps=0.93 w=0.65 l=0.15
X1 a_113_297# A2 VPWR VPB sky130_fd_pr__pfet_01v8_hvt ad=0.265 pd=2.53 as=0.1475 ps=1.295 w=1 l=0.15
X2 Y B1 VGND VNB sky130_fd_pr__nfet_01v8 ad=0.091 pd=0.93 as=0.17225 ps=1.83 w=0.65 l=0.15
X3 VPWR A1 a_113_297# VPB sky130_fd_pr__pfet_01v8_hvt ad=0.1475 pd=1.295 as=0.14 ps=1.28 w=1 l=0.15
X4 a_113_297# B1 Y VPB sky130_fd_pr__pfet_01v8_hvt ad=0.14 pd=1.28 as=0.265 ps=2.53 w=1 l=0.15
X5 VGND A2 a_199_47# VNB sky130_fd_pr__nfet_01v8 ad=0.17225 pd=1.83 as=0.095875 ps=0.945 w=0.65 l=0.15
.ends

.subckt X2_sky130_fd_sc_hd__and4b_1 VGND VPWR C A_N X D B VPB VNB
X0 a_297_47# a_27_47# a_193_413# VNB sky130_fd_pr__nfet_01v8 ad=0.0441 pd=0.63 as=0.1092 ps=1.36 w=0.42 l=0.15
X1 a_369_47# B a_297_47# VNB sky130_fd_pr__nfet_01v8 ad=0.0735 pd=0.77 as=0.0441 ps=0.63 w=0.42 l=0.15
X2 VPWR D a_193_413# VPB sky130_fd_pr__pfet_01v8_hvt ad=0.14075 pd=1.325 as=0.06615 ps=0.735 w=0.42 l=0.15
X3 X a_193_413# VGND VNB sky130_fd_pr__nfet_01v8 ad=0.169 pd=1.82 as=0.1034 ps=1 w=0.65 l=0.15
X4 VPWR A_N a_27_47# VPB sky130_fd_pr__pfet_01v8_hvt ad=0.0567 pd=0.69 as=0.1092 ps=1.36 w=0.42 l=0.15
X5 VGND D a_469_47# VNB sky130_fd_pr__nfet_01v8 ad=0.1034 pd=1 as=0.0609 ps=0.71 w=0.42 l=0.15
X6 X a_193_413# VPWR VPB sky130_fd_pr__pfet_01v8_hvt ad=0.26 pd=2.52 as=0.14075 ps=1.325 w=1 l=0.15
X7 VPWR B a_193_413# VPB sky130_fd_pr__pfet_01v8_hvt ad=0.1281 pd=1.03 as=0.0987 ps=0.89 w=0.42 l=0.15
X8 a_193_413# C VPWR VPB sky130_fd_pr__pfet_01v8_hvt ad=0.06615 pd=0.735 as=0.1281 ps=1.03 w=0.42 l=0.15
X9 a_193_413# a_27_47# VPWR VPB sky130_fd_pr__pfet_01v8_hvt ad=0.0987 pd=0.89 as=0.0567 ps=0.69 w=0.42 l=0.15
X10 a_469_47# C a_369_47# VNB sky130_fd_pr__nfet_01v8 ad=0.0609 pd=0.71 as=0.0735 ps=0.77 w=0.42 l=0.15
X11 VGND A_N a_27_47# VNB sky130_fd_pr__nfet_01v8 ad=0.1092 pd=1.36 as=0.1092 ps=1.36 w=0.42 l=0.15
.ends

.subckt X2_sky130_fd_sc_hd__nand2_8 VNB VPB VGND VPWR A Y B
X0 a_27_47# B VGND VNB sky130_fd_pr__nfet_01v8 ad=0.08775 pd=0.92 as=0.08775 ps=0.92 w=0.65 l=0.15 M=8
X1 Y A VPWR VPB sky130_fd_pr__pfet_01v8_hvt ad=0.135 pd=1.27 as=0.135 ps=1.27 w=1 l=0.15 M=8
X2 a_27_47# A Y VNB sky130_fd_pr__nfet_01v8 ad=0.08775 pd=0.92 as=0.08775 ps=0.92 w=0.65 l=0.15 M=8
X3 Y B VPWR VPB sky130_fd_pr__pfet_01v8_hvt ad=0.135 pd=1.27 as=0.135 ps=1.27 w=1 l=0.15 M=8
.ends

.subckt X2_sky130_fd_sc_hd__dfrtp_4 VGND VPWR VPB VNB CLK D RESET_B Q
X0 a_805_47# a_761_289# a_639_47# VNB sky130_fd_pr__nfet_01v8 ad=0.0441 pd=0.63 as=0.1401 ps=1.1 w=0.42 l=0.15
X1 a_1217_47# a_27_47# a_1108_47# VNB sky130_fd_pr__special_nfet_01v8 ad=0.0669 pd=0.75 as=0.0711 ps=0.755 w=0.36 l=0.15
X2 a_1283_21# a_1108_47# a_1462_47# VNB sky130_fd_pr__nfet_01v8 ad=0.1092 pd=1.36 as=0.06405 ps=0.725 w=0.42 l=0.15
X3 a_651_413# a_27_47# a_543_47# VPB sky130_fd_pr__pfet_01v8_hvt ad=0.1155 pd=0.97 as=0.07245 ps=0.765 w=0.42 l=0.15
X4 a_1108_47# a_193_47# a_761_289# VNB sky130_fd_pr__special_nfet_01v8 ad=0.0711 pd=0.755 as=0.0999 ps=0.985 w=0.36 l=0.15
X5 VGND RESET_B a_805_47# VNB sky130_fd_pr__nfet_01v8 ad=0.1346 pd=1.15 as=0.0441 ps=0.63 w=0.42 l=0.15
X6 VPWR a_1283_21# Q VPB sky130_fd_pr__pfet_01v8_hvt ad=0.305 pd=2.61 as=0.135 ps=1.27 w=1 l=0.15 M=4
X7 VPWR CLK a_27_47# VPB sky130_fd_pr__pfet_01v8_hvt ad=0.0864 pd=0.91 as=0.1664 ps=1.8 w=0.64 l=0.15
X8 a_448_47# D VPWR VPB sky130_fd_pr__pfet_01v8_hvt ad=0.0651 pd=0.73 as=0.1092 ps=1.36 w=0.42 l=0.15
X9 a_761_289# a_543_47# VGND VNB sky130_fd_pr__nfet_01v8 ad=0.0999 pd=0.985 as=0.1346 ps=1.15 w=0.64 l=0.15
X10 Q a_1283_21# VGND VNB sky130_fd_pr__nfet_01v8 ad=0.08775 pd=0.92 as=0.169 ps=1.82 w=0.65 l=0.15 M=4
X11 a_193_47# a_27_47# VGND VNB sky130_fd_pr__nfet_01v8 ad=0.1092 pd=1.36 as=0.0567 ps=0.69 w=0.42 l=0.15
X12 a_1108_47# a_27_47# a_761_289# VPB sky130_fd_pr__pfet_01v8_hvt ad=0.0588 pd=0.7 as=0.12915 ps=1.185 w=0.42 l=0.15
X13 a_1462_47# RESET_B VGND VNB sky130_fd_pr__nfet_01v8 ad=0.06405 pd=0.725 as=0.12495 ps=1.015 w=0.42 l=0.15
X14 a_543_47# a_27_47# a_448_47# VNB sky130_fd_pr__special_nfet_01v8 ad=0.0594 pd=0.69 as=0.066 ps=0.745 w=0.36 l=0.15
X15 a_543_47# a_193_47# a_448_47# VPB sky130_fd_pr__pfet_01v8_hvt ad=0.07245 pd=0.765 as=0.0651 ps=0.73 w=0.42 l=0.15
X16 a_448_47# D VGND VNB sky130_fd_pr__nfet_01v8 ad=0.066 pd=0.745 as=0.2205 ps=1.89 w=0.42 l=0.15
X17 VPWR a_1283_21# a_1270_413# VPB sky130_fd_pr__pfet_01v8_hvt ad=0.0819 pd=0.81 as=0.0567 ps=0.69 w=0.42 l=0.15
X18 VPWR a_1108_47# a_1283_21# VPB sky130_fd_pr__pfet_01v8_hvt ad=0.1134 pd=1.38 as=0.0567 ps=0.69 w=0.42 l=0.15
X19 a_1270_413# a_193_47# a_1108_47# VPB sky130_fd_pr__pfet_01v8_hvt ad=0.0567 pd=0.69 as=0.0588 ps=0.7 w=0.42 l=0.15
X20 a_193_47# a_27_47# VPWR VPB sky130_fd_pr__pfet_01v8_hvt ad=0.1664 pd=1.8 as=0.0864 ps=0.91 w=0.64 l=0.15
X21 a_1283_21# RESET_B VPWR VPB sky130_fd_pr__pfet_01v8_hvt ad=0.0567 pd=0.69 as=0.0819 ps=0.81 w=0.42 l=0.15
X22 VPWR a_761_289# a_651_413# VPB sky130_fd_pr__pfet_01v8_hvt ad=0.07035 pd=0.755 as=0.1155 ps=0.97 w=0.42 l=0.15
X23 a_639_47# a_193_47# a_543_47# VNB sky130_fd_pr__special_nfet_01v8 ad=0.1401 pd=1.1 as=0.0594 ps=0.69 w=0.36 l=0.15
X24 VGND a_1283_21# a_1217_47# VNB sky130_fd_pr__nfet_01v8 ad=0.12495 pd=1.015 as=0.0669 ps=0.75 w=0.42 l=0.15
X25 a_651_413# RESET_B VPWR VPB sky130_fd_pr__pfet_01v8_hvt ad=0.1092 pd=1.36 as=0.07035 ps=0.755 w=0.42 l=0.15
X26 VGND CLK a_27_47# VNB sky130_fd_pr__nfet_01v8 ad=0.0567 pd=0.69 as=0.1092 ps=1.36 w=0.42 l=0.15
X27 a_761_289# a_543_47# VPWR VPB sky130_fd_pr__pfet_01v8_hvt ad=0.12915 pd=1.185 as=0.2184 ps=2.2 w=0.84 l=0.15
.ends

.subckt X2_sky130_fd_sc_hd__clkinv_2 VNB VPB VPWR VGND A Y
X0 Y A VGND VNB sky130_fd_pr__nfet_01v8 ad=0.0588 pd=0.7 as=0.1113 ps=1.37 w=0.42 l=0.15 M=2
X1 Y A VPWR VPB sky130_fd_pr__pfet_01v8_hvt ad=0.14 pd=1.28 as=0.14 ps=1.28 w=1 l=0.15 M=3
.ends

.subckt X2_sky130_fd_sc_hd__and3_4 VNB VPB VGND VPWR X A B C
X0 VPWR A a_94_47# VPB sky130_fd_pr__pfet_01v8_hvt ad=0.1975 pd=1.395 as=0.305 ps=2.61 w=1 l=0.15
X1 a_294_47# B a_185_47# VNB sky130_fd_pr__nfet_01v8 ad=0.06825 pd=0.86 as=0.128375 ps=1.045 w=0.65 l=0.15
X2 a_185_47# A a_94_47# VNB sky130_fd_pr__nfet_01v8 ad=0.128375 pd=1.045 as=0.19825 ps=1.91 w=0.65 l=0.15
X3 VPWR a_94_47# X VPB sky130_fd_pr__pfet_01v8_hvt ad=0.285 pd=2.57 as=0.14 ps=1.28 w=1 l=0.15 M=4
X4 VGND C a_294_47# VNB sky130_fd_pr__nfet_01v8 ad=0.138125 pd=1.075 as=0.06825 ps=0.86 w=0.65 l=0.15
X5 a_94_47# B VPWR VPB sky130_fd_pr__pfet_01v8_hvt ad=0.14 pd=1.28 as=0.1975 ps=1.395 w=1 l=0.15
X6 X a_94_47# VGND VNB sky130_fd_pr__nfet_01v8 ad=0.091 pd=0.93 as=0.091 ps=0.93 w=0.65 l=0.15 M=4
X7 VPWR C a_94_47# VPB sky130_fd_pr__pfet_01v8_hvt ad=0.1775 pd=1.355 as=0.14 ps=1.28 w=1 l=0.15
.ends

.subckt X2_sky130_fd_sc_hd__buf_8 VPB VNB VGND VPWR A X
X0 X a_27_47# VGND VNB sky130_fd_pr__nfet_01v8 ad=0.08775 pd=0.92 as=0.08775 ps=0.92 w=0.65 l=0.15 M=8
X1 VPWR a_27_47# X VPB sky130_fd_pr__pfet_01v8_hvt ad=0.135 pd=1.27 as=0.135 ps=1.27 w=1 l=0.15 M=8
X2 VPWR A a_27_47# VPB sky130_fd_pr__pfet_01v8_hvt ad=0.135 pd=1.27 as=0.135 ps=1.27 w=1 l=0.15 M=3
X3 a_27_47# A VGND VNB sky130_fd_pr__nfet_01v8 ad=0.08775 pd=0.92 as=0.08775 ps=0.92 w=0.65 l=0.15 M=3
.ends

.subckt X2_sky130_fd_sc_hd__clkinv_4 VNB VPB VPWR VGND A Y
X0 Y A VPWR VPB sky130_fd_pr__pfet_01v8_hvt ad=0.14 pd=1.28 as=0.14 ps=1.28 w=1 l=0.15 M=6
X1 VGND A Y VNB sky130_fd_pr__nfet_01v8 ad=0.1659 pd=1.63 as=0.0588 ps=0.7 w=0.42 l=0.15 M=4
.ends

.subckt X2_sky130_fd_sc_hd__nor4_2 VNB VPB VGND VPWR B D Y A C
X0 a_281_297# B a_27_297# VPB sky130_fd_pr__pfet_01v8_hvt ad=0.135 pd=1.27 as=0.135 ps=1.27 w=1 l=0.15 M=2
X1 Y B VGND VNB sky130_fd_pr__nfet_01v8 ad=0.08775 pd=0.92 as=0.08775 ps=0.92 w=0.65 l=0.15 M=2
X2 a_27_297# A VPWR VPB sky130_fd_pr__pfet_01v8_hvt ad=0.135 pd=1.27 as=0.135 ps=1.27 w=1 l=0.15 M=2
X3 a_475_297# D Y VPB sky130_fd_pr__pfet_01v8_hvt ad=0.26 pd=2.52 as=0.135 ps=1.27 w=1 l=0.15 M=2
X4 VGND C Y VNB sky130_fd_pr__nfet_01v8 ad=0.08775 pd=0.92 as=0.08775 ps=0.92 w=0.65 l=0.15 M=2
X5 VGND D Y VNB sky130_fd_pr__nfet_01v8 ad=0.169 pd=1.82 as=0.08775 ps=0.92 w=0.65 l=0.15 M=2
X6 VGND A Y VNB sky130_fd_pr__nfet_01v8 ad=0.08775 pd=0.92 as=0.08775 ps=0.92 w=0.65 l=0.15 M=2
X7 a_475_297# C a_281_297# VPB sky130_fd_pr__pfet_01v8_hvt ad=0.135 pd=1.27 as=0.135 ps=1.27 w=1 l=0.15 M=2
.ends

.subckt X2_sky130_fd_sc_hd__nor2_1 VPB VNB VGND VPWR A B Y
X0 VPWR A a_109_297# VPB sky130_fd_pr__pfet_01v8_hvt ad=0.26 pd=2.52 as=0.105 ps=1.21 w=1 l=0.15
X1 VGND A Y VNB sky130_fd_pr__nfet_01v8 ad=0.169 pd=1.82 as=0.08775 ps=0.92 w=0.65 l=0.15
X2 a_109_297# B Y VPB sky130_fd_pr__pfet_01v8_hvt ad=0.105 pd=1.21 as=0.26 ps=2.52 w=1 l=0.15
X3 Y B VGND VNB sky130_fd_pr__nfet_01v8 ad=0.08775 pd=0.92 as=0.169 ps=1.82 w=0.65 l=0.15
.ends

.subckt X2_sky130_fd_sc_hd__clkbuf_8 X A VPB VNB VGND VPWR
X0 VPWR A a_110_47# VPB sky130_fd_pr__pfet_01v8_hvt ad=0.14 pd=1.28 as=0.14 ps=1.28 w=1 l=0.15 M=2
X1 VPWR a_110_47# X VPB sky130_fd_pr__pfet_01v8_hvt ad=0.14 pd=1.28 as=0.14 ps=1.28 w=1 l=0.15 M=8
X2 X a_110_47# VGND VNB sky130_fd_pr__nfet_01v8 ad=0.0588 pd=0.7 as=0.0588 ps=0.7 w=0.42 l=0.15 M=8
X3 VGND A a_110_47# VNB sky130_fd_pr__nfet_01v8 ad=0.0588 pd=0.7 as=0.0588 ps=0.7 w=0.42 l=0.15 M=2
.ends

.subckt X2_sky130_fd_sc_hd__inv_6 VPB VNB VPWR VGND Y A
X0 VPWR A Y VPB sky130_fd_pr__pfet_01v8_hvt ad=0.27 pd=2.54 as=0.135 ps=1.27 w=1 l=0.15 M=6
X1 Y A VGND VNB sky130_fd_pr__nfet_01v8 ad=0.08775 pd=0.92 as=0.08775 ps=0.92 w=0.65 l=0.15 M=6
.ends

.subckt X2_sky130_fd_sc_hd__and2_4 VNB VPB VGND VPWR A X B
X0 VPWR B a_27_47# VPB sky130_fd_pr__pfet_01v8_hvt ad=0.1775 pd=1.355 as=0.14 ps=1.28 w=1 l=0.15
X1 a_27_47# A VPWR VPB sky130_fd_pr__pfet_01v8_hvt ad=0.14 pd=1.28 as=0.265 ps=2.53 w=1 l=0.15
X2 X a_27_47# VGND VNB sky130_fd_pr__nfet_01v8 ad=0.091 pd=0.93 as=0.138125 ps=1.075 w=0.65 l=0.15 M=4
X3 VPWR a_27_47# X VPB sky130_fd_pr__pfet_01v8_hvt ad=0.14 pd=1.28 as=0.14 ps=1.28 w=1 l=0.15 M=4
X4 VGND B a_110_47# VNB sky130_fd_pr__nfet_01v8 ad=0.138125 pd=1.075 as=0.06825 ps=0.86 w=0.65 l=0.15
X5 a_110_47# A a_27_47# VNB sky130_fd_pr__nfet_01v8 ad=0.06825 pd=0.86 as=0.17225 ps=1.83 w=0.65 l=0.15
.ends

.subckt X2_sky130_fd_sc_hd__o21ai_2 VGND VPWR B1 A1 Y A2 VPB VNB
X0 VGND A2 a_29_47# VNB sky130_fd_pr__nfet_01v8 ad=0.12675 pd=1.04 as=0.091 ps=0.93 w=0.65 l=0.15 M=2
X1 Y B1 a_29_47# VNB sky130_fd_pr__nfet_01v8 ad=0.091 pd=0.93 as=0.091 ps=0.93 w=0.65 l=0.15 M=2
X2 VPWR B1 Y VPB sky130_fd_pr__pfet_01v8_hvt ad=0.265 pd=2.53 as=0.14 ps=1.28 w=1 l=0.15 M=2
X3 VPWR A1 a_112_297# VPB sky130_fd_pr__pfet_01v8_hvt ad=0.16 pd=1.32 as=0.175 ps=1.35 w=1 l=0.15 M=2
X4 Y A2 a_112_297# VPB sky130_fd_pr__pfet_01v8_hvt ad=0.14 pd=1.28 as=0.14 ps=1.28 w=1 l=0.15 M=2
X5 VGND A1 a_29_47# VNB sky130_fd_pr__nfet_01v8 ad=0.091 pd=0.93 as=0.17225 ps=1.83 w=0.65 l=0.15 M=2
.ends

.subckt X2_sky130_fd_sc_hd__and4_4 VNB VPB VGND VPWR X D C B A
X0 VPWR a_27_47# X VPB sky130_fd_pr__pfet_01v8_hvt ad=0.26 pd=2.52 as=0.135 ps=1.27 w=1 l=0.15 M=4
X1 a_188_47# B a_109_47# VNB sky130_fd_pr__nfet_01v8 ad=0.108875 pd=0.985 as=0.079625 ps=0.895 w=0.65 l=0.15
X2 VGND D a_285_47# VNB sky130_fd_pr__nfet_01v8 ad=0.105625 pd=0.975 as=0.141375 ps=1.085 w=0.65 l=0.15
X3 VPWR D a_27_47# VPB sky130_fd_pr__pfet_01v8_hvt ad=0.165 pd=1.33 as=0.215 ps=1.43 w=1 l=0.15
X4 VGND a_27_47# X VNB sky130_fd_pr__nfet_01v8 ad=0.08775 pd=0.92 as=0.08775 ps=0.92 w=0.65 l=0.15 M=4
X5 VPWR B a_27_47# VPB sky130_fd_pr__pfet_01v8_hvt ad=0.155 pd=1.31 as=0.135 ps=1.27 w=1 l=0.15
X6 a_27_47# C VPWR VPB sky130_fd_pr__pfet_01v8_hvt ad=0.215 pd=1.43 as=0.155 ps=1.31 w=1 l=0.15
X7 a_27_47# A VPWR VPB sky130_fd_pr__pfet_01v8_hvt ad=0.135 pd=1.27 as=0.26 ps=2.52 w=1 l=0.15
X8 a_285_47# C a_188_47# VNB sky130_fd_pr__nfet_01v8 ad=0.141375 pd=1.085 as=0.108875 ps=0.985 w=0.65 l=0.15
X9 a_109_47# A a_27_47# VNB sky130_fd_pr__nfet_01v8 ad=0.079625 pd=0.895 as=0.169 ps=1.82 w=0.65 l=0.15
.ends

.subckt X2_sky130_fd_sc_hd__a21boi_1 VPWR VGND VPB VNB B1_N Y A1 A2
X0 a_300_297# a_27_413# Y VPB sky130_fd_pr__pfet_01v8_hvt ad=0.14 pd=1.28 as=0.265 ps=2.53 w=1 l=0.15
X1 VGND A2 a_384_47# VNB sky130_fd_pr__nfet_01v8 ad=0.17225 pd=1.83 as=0.091 ps=0.93 w=0.65 l=0.15
X2 VPWR B1_N a_27_413# VPB sky130_fd_pr__pfet_01v8_hvt ad=0.1113 pd=1.37 as=0.1113 ps=1.37 w=0.42 l=0.15
X3 Y a_27_413# VGND VNB sky130_fd_pr__nfet_01v8 ad=0.143 pd=1.09 as=0.101875 ps=0.99 w=0.65 l=0.15
X4 VPWR A1 a_300_297# VPB sky130_fd_pr__pfet_01v8_hvt ad=0.14 pd=1.28 as=0.14 ps=1.28 w=1 l=0.15
X5 a_384_47# A1 Y VNB sky130_fd_pr__nfet_01v8 ad=0.091 pd=0.93 as=0.143 ps=1.09 w=0.65 l=0.15
X6 VGND B1_N a_27_413# VNB sky130_fd_pr__nfet_01v8 ad=0.101875 pd=0.99 as=0.1113 ps=1.37 w=0.42 l=0.15
X7 a_300_297# A2 VPWR VPB sky130_fd_pr__pfet_01v8_hvt ad=0.265 pd=2.53 as=0.14 ps=1.28 w=1 l=0.15
.ends

.subckt X2_sky130_fd_sc_hd__or2_4 VNB VPB VGND VPWR B A X
X0 a_121_297# B a_35_297# VPB sky130_fd_pr__pfet_01v8_hvt ad=0.105 pd=1.21 as=0.28 ps=2.56 w=1 l=0.15
X1 VPWR a_35_297# X VPB sky130_fd_pr__pfet_01v8_hvt ad=0.28 pd=2.56 as=0.135 ps=1.27 w=1 l=0.15 M=4
X2 X a_35_297# VGND VNB sky130_fd_pr__nfet_01v8 ad=0.08775 pd=0.92 as=0.115375 ps=1.005 w=0.65 l=0.15 M=4
X3 VPWR A a_121_297# VPB sky130_fd_pr__pfet_01v8_hvt ad=0.1775 pd=1.355 as=0.105 ps=1.21 w=1 l=0.15
X4 VGND A a_35_297# VNB sky130_fd_pr__nfet_01v8 ad=0.115375 pd=1.005 as=0.08775 ps=0.92 w=0.65 l=0.15
X5 a_35_297# B VGND VNB sky130_fd_pr__nfet_01v8 ad=0.08775 pd=0.92 as=0.169 ps=1.82 w=0.65 l=0.15
.ends

.subckt X2_sky130_fd_sc_hd__and3b_1 A_N B X C VGND VPWR VPB VNB
X0 a_109_93# A_N VGND VNB sky130_fd_pr__nfet_01v8 ad=0.10785 pd=1.36 as=0.1092 ps=1.36 w=0.42 l=0.15
X1 X a_209_311# VPWR VPB sky130_fd_pr__pfet_01v8_hvt ad=0.26 pd=2.52 as=0.142225 ps=1.335 w=1 l=0.15
X2 a_109_93# A_N VPWR VPB sky130_fd_pr__pfet_01v8_hvt ad=0.1087 pd=1.36 as=0.1092 ps=1.36 w=0.42 l=0.15
X3 a_296_53# a_109_93# a_209_311# VNB sky130_fd_pr__nfet_01v8 ad=0.0441 pd=0.63 as=0.107825 ps=1.36 w=0.42 l=0.15
X4 VPWR C a_209_311# VPB sky130_fd_pr__pfet_01v8_hvt ad=0.142225 pd=1.335 as=0.074375 ps=0.815 w=0.42 l=0.15
X5 a_368_53# B a_296_53# VNB sky130_fd_pr__nfet_01v8 ad=0.05355 pd=0.675 as=0.0441 ps=0.63 w=0.42 l=0.15
X6 X a_209_311# VGND VNB sky130_fd_pr__nfet_01v8 ad=0.169 pd=1.82 as=0.122275 ps=1.08 w=0.65 l=0.15
X7 a_209_311# B VPWR VPB sky130_fd_pr__pfet_01v8_hvt ad=0.074375 pd=0.815 as=0.0567 ps=0.69 w=0.42 l=0.15
X8 VPWR a_109_93# a_209_311# VPB sky130_fd_pr__pfet_01v8_hvt ad=0.0567 pd=0.69 as=0.1085 ps=1.36 w=0.42 l=0.15
X9 VGND C a_368_53# VNB sky130_fd_pr__nfet_01v8 ad=0.122275 pd=1.08 as=0.05355 ps=0.675 w=0.42 l=0.15
.ends

.subckt X2_sky130_fd_sc_hd__bufinv_16 VNB VPB VGND VPWR A Y
X0 a_361_47# a_27_47# VGND VNB sky130_fd_pr__nfet_01v8 ad=0.08775 pd=0.92 as=0.08775 ps=0.92 w=0.65 l=0.15 M=6
X1 VPWR a_361_47# Y VPB sky130_fd_pr__pfet_01v8_hvt ad=0.135 pd=1.27 as=0.135 ps=1.27 w=1 l=0.15 M=16
X2 Y a_361_47# VGND VNB sky130_fd_pr__nfet_01v8 ad=0.08775 pd=0.92 as=0.08775 ps=0.92 w=0.65 l=0.15 M=16
X3 VPWR a_27_47# a_361_47# VPB sky130_fd_pr__pfet_01v8_hvt ad=0.135 pd=1.27 as=0.135 ps=1.27 w=1 l=0.15 M=6
X4 VPWR A a_27_47# VPB sky130_fd_pr__pfet_01v8_hvt ad=0.135 pd=1.27 as=0.135 ps=1.27 w=1 l=0.15 M=3
X5 a_27_47# A VGND VNB sky130_fd_pr__nfet_01v8 ad=0.08775 pd=0.92 as=0.08775 ps=0.92 w=0.65 l=0.15 M=3
.ends

.subckt X2_sky130_fd_sc_hd__nor2_8 VPB VNB VGND VPWR A B Y
X0 VPWR A a_27_297# VPB sky130_fd_pr__pfet_01v8_hvt ad=0.135 pd=1.27 as=0.135 ps=1.27 w=1 l=0.15 M=8
X1 Y B a_27_297# VPB sky130_fd_pr__pfet_01v8_hvt ad=0.135 pd=1.27 as=0.135 ps=1.27 w=1 l=0.15 M=8
X2 Y A VGND VNB sky130_fd_pr__nfet_01v8 ad=0.08775 pd=0.92 as=0.08775 ps=0.92 w=0.65 l=0.15 M=8
X3 Y B VGND VNB sky130_fd_pr__nfet_01v8 ad=0.08775 pd=0.92 as=0.08775 ps=0.92 w=0.65 l=0.15 M=8
.ends

.subckt X2_sky130_fd_sc_hd__a31o_1 VPB VNB X A3 A2 A1 B1 VGND VPWR
X0 VPWR a_80_21# X VPB sky130_fd_pr__pfet_01v8_hvt ad=0.1725 pd=1.345 as=0.265 ps=2.53 w=1 l=0.15
X1 a_209_297# A3 VPWR VPB sky130_fd_pr__pfet_01v8_hvt ad=0.16 pd=1.32 as=0.1725 ps=1.345 w=1 l=0.15
X2 a_303_47# A2 a_209_47# VNB sky130_fd_pr__nfet_01v8 ad=0.10725 pd=0.98 as=0.104 ps=0.97 w=0.65 l=0.15
X3 a_209_47# A3 VGND VNB sky130_fd_pr__nfet_01v8 ad=0.104 pd=0.97 as=0.112125 ps=0.995 w=0.65 l=0.15
X4 VGND a_80_21# X VNB sky130_fd_pr__nfet_01v8 ad=0.112125 pd=0.995 as=0.17225 ps=1.83 w=0.65 l=0.15
X5 VGND B1 a_80_21# VNB sky130_fd_pr__nfet_01v8 ad=0.208 pd=1.94 as=0.10725 ps=0.98 w=0.65 l=0.15
X6 a_80_21# A1 a_303_47# VNB sky130_fd_pr__nfet_01v8 ad=0.10725 pd=0.98 as=0.10725 ps=0.98 w=0.65 l=0.15
X7 VPWR A2 a_209_297# VPB sky130_fd_pr__pfet_01v8_hvt ad=0.165 pd=1.33 as=0.16 ps=1.32 w=1 l=0.15
X8 a_80_21# B1 a_209_297# VPB sky130_fd_pr__pfet_01v8_hvt ad=0.32 pd=2.64 as=0.165 ps=1.33 w=1 l=0.15
X9 a_209_297# A1 VPWR VPB sky130_fd_pr__pfet_01v8_hvt ad=0.165 pd=1.33 as=0.165 ps=1.33 w=1 l=0.15
.ends

.subckt X2_sky130_fd_sc_hd__buf_4 VPWR VGND X A VPB VNB
X0 VPWR a_27_47# X VPB sky130_fd_pr__pfet_01v8_hvt ad=0.26 pd=2.52 as=0.135 ps=1.27 w=1 l=0.15 M=4
X1 X a_27_47# VGND VNB sky130_fd_pr__nfet_01v8 ad=0.08775 pd=0.92 as=0.08775 ps=0.92 w=0.65 l=0.15 M=4
X2 VPWR A a_27_47# VPB sky130_fd_pr__pfet_01v8_hvt ad=0.135 pd=1.27 as=0.26 ps=2.52 w=1 l=0.15
X3 VGND A a_27_47# VNB sky130_fd_pr__nfet_01v8 ad=0.08775 pd=0.92 as=0.169 ps=1.82 w=0.65 l=0.15
.ends

.subckt X2_sky130_fd_sc_hd__o31a_1 X A1 A2 A3 B1 VPB VNB VGND VPWR
X0 a_103_199# B1 a_253_47# VNB sky130_fd_pr__nfet_01v8 ad=0.2015 pd=1.92 as=0.10725 ps=0.98 w=0.65 l=0.15
X1 VPWR a_103_199# X VPB sky130_fd_pr__pfet_01v8_hvt ad=0.195 pd=1.39 as=0.36 ps=2.72 w=1 l=0.15
X2 a_337_297# A2 a_253_297# VPB sky130_fd_pr__pfet_01v8_hvt ad=0.165 pd=1.33 as=0.135 ps=1.27 w=1 l=0.15
X3 a_103_199# A3 a_337_297# VPB sky130_fd_pr__pfet_01v8_hvt ad=0.2125 pd=1.425 as=0.165 ps=1.33 w=1 l=0.15
X4 a_253_297# A1 VPWR VPB sky130_fd_pr__pfet_01v8_hvt ad=0.135 pd=1.27 as=0.195 ps=1.39 w=1 l=0.15
X5 VPWR B1 a_103_199# VPB sky130_fd_pr__pfet_01v8_hvt ad=0.345 pd=2.69 as=0.2125 ps=1.425 w=1 l=0.15
X6 VGND a_103_199# X VNB sky130_fd_pr__nfet_01v8 ad=0.12675 pd=1.04 as=0.234 ps=2.02 w=0.65 l=0.15
X7 a_253_47# A1 VGND VNB sky130_fd_pr__nfet_01v8 ad=0.08775 pd=0.92 as=0.12675 ps=1.04 w=0.65 l=0.15
X8 a_253_47# A3 VGND VNB sky130_fd_pr__nfet_01v8 ad=0.10725 pd=0.98 as=0.10725 ps=0.98 w=0.65 l=0.15
X9 VGND A2 a_253_47# VNB sky130_fd_pr__nfet_01v8 ad=0.10725 pd=0.98 as=0.08775 ps=0.92 w=0.65 l=0.15
.ends

.subckt X2_sky130_fd_sc_hd__nand2_1 VPB VNB VGND VPWR A Y B
X0 VPWR A Y VPB sky130_fd_pr__pfet_01v8_hvt ad=0.26 pd=2.52 as=0.135 ps=1.27 w=1 l=0.15
X1 Y A a_113_47# VNB sky130_fd_pr__nfet_01v8 ad=0.169 pd=1.82 as=0.08775 ps=0.92 w=0.65 l=0.15
X2 a_113_47# B VGND VNB sky130_fd_pr__nfet_01v8 ad=0.08775 pd=0.92 as=0.169 ps=1.82 w=0.65 l=0.15
X3 Y B VPWR VPB sky130_fd_pr__pfet_01v8_hvt ad=0.135 pd=1.27 as=0.26 ps=2.52 w=1 l=0.15
.ends

.subckt X2_sky130_fd_sc_hd__or4bb_1 VPWR VGND VPB VNB B A X D_N C_N
X0 VGND A a_311_413# VNB sky130_fd_pr__nfet_01v8 ad=0.101875 pd=0.99 as=0.0567 ps=0.69 w=0.42 l=0.15
X1 VPWR A a_561_297# VPB sky130_fd_pr__pfet_01v8_hvt ad=0.14825 pd=1.34 as=0.05985 ps=0.705 w=0.42 l=0.15
X2 a_393_413# a_205_93# a_311_413# VPB sky130_fd_pr__pfet_01v8_hvt ad=0.1215 pd=1.33 as=0.1092 ps=1.36 w=0.42 l=0.15
X3 VGND C_N a_27_410# VNB sky130_fd_pr__nfet_01v8 ad=0.06195 pd=0.715 as=0.1092 ps=1.36 w=0.42 l=0.15
X4 VPWR C_N a_27_410# VPB sky130_fd_pr__pfet_01v8_hvt ad=0.1226 pd=1.32 as=0.1092 ps=1.36 w=0.42 l=0.15
X5 X a_311_413# VPWR VPB sky130_fd_pr__pfet_01v8_hvt ad=0.275 pd=2.55 as=0.14825 ps=1.34 w=1 l=0.15
X6 VGND a_27_410# a_311_413# VNB sky130_fd_pr__nfet_01v8 ad=0.0567 pd=0.69 as=0.05985 ps=0.705 w=0.42 l=0.15
X7 a_561_297# B a_489_297# VPB sky130_fd_pr__pfet_01v8_hvt ad=0.05985 pd=0.705 as=0.0441 ps=0.63 w=0.42 l=0.15
X8 a_205_93# D_N VGND VNB sky130_fd_pr__nfet_01v8 ad=0.1092 pd=1.36 as=0.06195 ps=0.715 w=0.42 l=0.15
X9 a_205_93# D_N VPWR VPB sky130_fd_pr__pfet_01v8_hvt ad=0.1176 pd=1.4 as=0.1226 ps=1.32 w=0.42 l=0.15
X10 a_489_297# a_27_410# a_393_413# VPB sky130_fd_pr__pfet_01v8_hvt ad=0.0441 pd=0.63 as=0.1215 ps=1.33 w=0.42 l=0.15
X11 a_311_413# B VGND VNB sky130_fd_pr__nfet_01v8 ad=0.0567 pd=0.69 as=0.0567 ps=0.69 w=0.42 l=0.15
X12 a_311_413# a_205_93# VGND VNB sky130_fd_pr__nfet_01v8 ad=0.05985 pd=0.705 as=0.1092 ps=1.36 w=0.42 l=0.15
X13 X a_311_413# VGND VNB sky130_fd_pr__nfet_01v8 ad=0.17875 pd=1.85 as=0.101875 ps=0.99 w=0.65 l=0.15
.ends

.subckt X2_sky130_fd_sc_hd__buf_1 VGND VPWR X A VPB VNB
X0 VPWR A a_27_47# VPB sky130_fd_pr__pfet_01v8_hvt ad=0.11455 pd=1.08 as=0.2054 ps=2.1 w=0.79 l=0.15
X1 X a_27_47# VGND VNB sky130_fd_pr__nfet_01v8 ad=0.1352 pd=1.56 as=0.0754 ps=0.81 w=0.52 l=0.15
X2 X a_27_47# VPWR VPB sky130_fd_pr__pfet_01v8_hvt ad=0.2054 pd=2.1 as=0.11455 ps=1.08 w=0.79 l=0.15
X3 VGND A a_27_47# VNB sky130_fd_pr__nfet_01v8 ad=0.0754 pd=0.81 as=0.1352 ps=1.56 w=0.52 l=0.15
.ends

.subckt X2_sky130_fd_sc_hd__and4bb_1 VNB VPB VGND VPWR A_N B_N C D X
X0 VPWR D a_343_93# VPB sky130_fd_pr__pfet_01v8_hvt ad=0.172 pd=1.46 as=0.0777 ps=0.79 w=0.42 l=0.15
X1 a_223_47# B_N VGND VNB sky130_fd_pr__nfet_01v8 ad=0.1386 pd=1.5 as=0.0588 ps=0.7 w=0.42 l=0.15
X2 a_515_93# a_223_47# a_429_93# VNB sky130_fd_pr__nfet_01v8 ad=0.0735 pd=0.77 as=0.0588 ps=0.7 w=0.42 l=0.15
X3 a_223_47# B_N VPWR VPB sky130_fd_pr__pfet_01v8_hvt ad=0.1344 pd=1.48 as=0.0588 ps=0.7 w=0.42 l=0.15
X4 VPWR A_N a_27_47# VPB sky130_fd_pr__pfet_01v8_hvt ad=0.0588 pd=0.7 as=0.168 ps=1.64 w=0.42 l=0.15
X5 VGND A_N a_27_47# VNB sky130_fd_pr__nfet_01v8 ad=0.0588 pd=0.7 as=0.168 ps=1.64 w=0.42 l=0.15
X6 X a_343_93# VPWR VPB sky130_fd_pr__pfet_01v8_hvt ad=0.26 pd=2.52 as=0.172 ps=1.46 w=1 l=0.15
X7 a_429_93# a_27_47# a_343_93# VNB sky130_fd_pr__nfet_01v8 ad=0.0588 pd=0.7 as=0.1176 ps=1.4 w=0.42 l=0.15
X8 VGND D a_615_93# VNB sky130_fd_pr__nfet_01v8 ad=0.1265 pd=1.11 as=0.0777 ps=0.79 w=0.42 l=0.15
X9 a_343_93# C VPWR VPB sky130_fd_pr__pfet_01v8_hvt ad=0.0777 pd=0.79 as=0.0735 ps=0.77 w=0.42 l=0.15
X10 a_343_93# a_27_47# VPWR VPB sky130_fd_pr__pfet_01v8_hvt ad=0.0588 pd=0.7 as=0.1218 ps=1.42 w=0.42 l=0.15
X11 a_615_93# C a_515_93# VNB sky130_fd_pr__nfet_01v8 ad=0.0777 pd=0.79 as=0.0735 ps=0.77 w=0.42 l=0.15
X12 X a_343_93# VGND VNB sky130_fd_pr__nfet_01v8 ad=0.1654 pd=1.82 as=0.1265 ps=1.11 w=0.65 l=0.15
X13 VPWR a_223_47# a_343_93# VPB sky130_fd_pr__pfet_01v8_hvt ad=0.0735 pd=0.77 as=0.0588 ps=0.7 w=0.42 l=0.15
.ends

.subckt X2_sky130_fd_sc_hd__o2bb2a_1 VNB VPB VPWR VGND X A1_N A2_N B2 B1
X0 a_206_369# A1_N VPWR VPB sky130_fd_pr__pfet_01v8_hvt ad=0.129 pd=1.18 as=0.14575 ps=1.335 w=0.42 l=0.15
X1 a_206_369# A2_N a_205_47# VNB sky130_fd_pr__nfet_01v8 ad=0.1092 pd=1.36 as=0.06615 ps=0.735 w=0.42 l=0.15
X2 VGND B2 a_489_47# VNB sky130_fd_pr__nfet_01v8 ad=0.0567 pd=0.69 as=0.0567 ps=0.69 w=0.42 l=0.15
X3 a_585_369# B2 a_76_199# VPB sky130_fd_pr__pfet_01v8_hvt ad=0.0441 pd=0.63 as=0.0672 ps=0.74 w=0.42 l=0.15
X4 a_489_47# a_206_369# a_76_199# VNB sky130_fd_pr__nfet_01v8 ad=0.0567 pd=0.69 as=0.1092 ps=1.36 w=0.42 l=0.15
X5 a_489_47# B1 VGND VNB sky130_fd_pr__nfet_01v8 ad=0.1092 pd=1.36 as=0.0567 ps=0.69 w=0.42 l=0.15
X6 VPWR A2_N a_206_369# VPB sky130_fd_pr__pfet_01v8_hvt ad=0.20925 pd=1.345 as=0.129 ps=1.18 w=0.42 l=0.15
X7 a_76_199# a_206_369# VPWR VPB sky130_fd_pr__pfet_01v8_hvt ad=0.0672 pd=0.74 as=0.20925 ps=1.345 w=0.42 l=0.15
X8 a_205_47# A1_N VGND VNB sky130_fd_pr__nfet_01v8 ad=0.06615 pd=0.735 as=0.098625 ps=0.98 w=0.42 l=0.15
X9 VPWR a_76_199# X VPB sky130_fd_pr__pfet_01v8_hvt ad=0.14575 pd=1.335 as=0.26 ps=2.52 w=1 l=0.15
X10 VPWR B1 a_585_369# VPB sky130_fd_pr__pfet_01v8_hvt ad=0.1092 pd=1.36 as=0.0441 ps=0.63 w=0.42 l=0.15
X11 VGND a_76_199# X VNB sky130_fd_pr__nfet_01v8 ad=0.098625 pd=0.98 as=0.169 ps=1.82 w=0.65 l=0.15
.ends

.subckt X2_sky130_fd_sc_hd__a21oi_2 VNB VPB VGND VPWR A2 A1 Y B1
X0 VGND A2 a_285_47# VNB sky130_fd_pr__nfet_01v8 ad=0.10725 pd=0.98 as=0.06825 ps=0.86 w=0.65 l=0.15
X1 VGND B1 Y VNB sky130_fd_pr__nfet_01v8 ad=0.26 pd=2.1 as=0.08775 ps=0.92 w=0.65 l=0.15 M=2
X2 Y A1 a_114_47# VNB sky130_fd_pr__nfet_01v8 ad=0.091 pd=0.93 as=0.089375 ps=0.925 w=0.65 l=0.15
X3 a_114_47# A2 VGND VNB sky130_fd_pr__nfet_01v8 ad=0.089375 pd=0.925 as=0.18525 ps=1.87 w=0.65 l=0.15
X4 a_27_297# B1 Y VPB sky130_fd_pr__pfet_01v8_hvt ad=0.36 pd=2.72 as=0.135 ps=1.27 w=1 l=0.15 M=2
X5 a_27_297# A1 VPWR VPB sky130_fd_pr__pfet_01v8_hvt ad=0.14 pd=1.28 as=0.14 ps=1.28 w=1 l=0.15 M=2
X6 VPWR A2 a_27_297# VPB sky130_fd_pr__pfet_01v8_hvt ad=0.14 pd=1.28 as=0.28 ps=2.56 w=1 l=0.15 M=2
X7 a_285_47# A1 Y VNB sky130_fd_pr__nfet_01v8 ad=0.06825 pd=0.86 as=0.091 ps=0.93 w=0.65 l=0.15
.ends

.subckt X2_sky130_fd_sc_hd__nand2b_1 VPB VNB VGND VPWR A_N B Y
X0 VGND A_N a_27_93# VNB sky130_fd_pr__nfet_01v8 ad=0.10025 pd=0.985 as=0.1092 ps=1.36 w=0.42 l=0.15
X1 Y a_27_93# a_206_47# VNB sky130_fd_pr__nfet_01v8 ad=0.169 pd=1.82 as=0.08775 ps=0.92 w=0.65 l=0.15
X2 a_206_47# B VGND VNB sky130_fd_pr__nfet_01v8 ad=0.08775 pd=0.92 as=0.10025 ps=0.985 w=0.65 l=0.15
X3 VPWR a_27_93# Y VPB sky130_fd_pr__pfet_01v8_hvt ad=0.265 pd=2.53 as=0.135 ps=1.27 w=1 l=0.15
X4 Y B VPWR VPB sky130_fd_pr__pfet_01v8_hvt ad=0.135 pd=1.27 as=0.14575 ps=1.335 w=1 l=0.15
X5 VPWR A_N a_27_93# VPB sky130_fd_pr__pfet_01v8_hvt ad=0.14575 pd=1.335 as=0.1092 ps=1.36 w=0.42 l=0.15
.ends

.subckt X2_sky130_fd_sc_hd__a211o_1 VNB VPB VGND VPWR X A2 B1 A1 C1
X0 VPWR a_80_21# X VPB sky130_fd_pr__pfet_01v8_hvt ad=0.265 pd=2.53 as=0.265 ps=2.53 w=1 l=0.15
X1 a_80_21# C1 a_472_297# VPB sky130_fd_pr__pfet_01v8_hvt ad=0.265 pd=2.53 as=0.155 ps=1.31 w=1 l=0.15
X2 VPWR A2 a_217_297# VPB sky130_fd_pr__pfet_01v8_hvt ad=0.14 pd=1.28 as=0.265 ps=2.53 w=1 l=0.15
X3 VGND B1 a_80_21# VNB sky130_fd_pr__nfet_01v8 ad=0.10075 pd=0.96 as=0.091 ps=0.93 w=0.65 l=0.15
X4 VGND a_80_21# X VNB sky130_fd_pr__nfet_01v8 ad=0.26 pd=1.45 as=0.17225 ps=1.83 w=0.65 l=0.15
X5 a_300_47# A2 VGND VNB sky130_fd_pr__nfet_01v8 ad=0.091 pd=0.93 as=0.26 ps=1.45 w=0.65 l=0.15
X6 a_217_297# A1 VPWR VPB sky130_fd_pr__pfet_01v8_hvt ad=0.14 pd=1.28 as=0.14 ps=1.28 w=1 l=0.15
X7 a_80_21# A1 a_300_47# VNB sky130_fd_pr__nfet_01v8 ad=0.091 pd=0.93 as=0.091 ps=0.93 w=0.65 l=0.15
X8 a_472_297# B1 a_217_297# VPB sky130_fd_pr__pfet_01v8_hvt ad=0.155 pd=1.31 as=0.14 ps=1.28 w=1 l=0.15
X9 a_80_21# C1 VGND VNB sky130_fd_pr__nfet_01v8 ad=0.17225 pd=1.83 as=0.10075 ps=0.96 w=0.65 l=0.15
.ends

.subckt X2_sky130_fd_sc_hd__a21o_1 VPWR VGND VPB VNB A2 A1 B1 X
X0 a_81_21# B1 VGND VNB sky130_fd_pr__nfet_01v8 ad=0.089375 pd=0.925 as=0.25675 ps=1.44 w=0.65 l=0.15
X1 a_299_297# B1 a_81_21# VPB sky130_fd_pr__pfet_01v8_hvt ad=0.1375 pd=1.275 as=0.26 ps=2.52 w=1 l=0.15
X2 VPWR a_81_21# X VPB sky130_fd_pr__pfet_01v8_hvt ad=0.26 pd=2.52 as=0.26 ps=2.52 w=1 l=0.15
X3 VPWR A1 a_299_297# VPB sky130_fd_pr__pfet_01v8_hvt ad=0.14 pd=1.28 as=0.1375 ps=1.275 w=1 l=0.15
X4 VGND a_81_21# X VNB sky130_fd_pr__nfet_01v8 ad=0.25675 pd=1.44 as=0.169 ps=1.82 w=0.65 l=0.15
X5 VGND A2 a_384_47# VNB sky130_fd_pr__nfet_01v8 ad=0.17225 pd=1.83 as=0.091 ps=0.93 w=0.65 l=0.15
X6 a_299_297# A2 VPWR VPB sky130_fd_pr__pfet_01v8_hvt ad=0.265 pd=2.53 as=0.14 ps=1.28 w=1 l=0.15
X7 a_384_47# A1 a_81_21# VNB sky130_fd_pr__nfet_01v8 ad=0.091 pd=0.93 as=0.089375 ps=0.925 w=0.65 l=0.15
.ends

.subckt X2_sky130_fd_sc_hd__clkbuf_2 VGND VPWR A X VPB VNB
X0 VPWR A a_27_47# VPB sky130_fd_pr__pfet_01v8_hvt ad=0.1625 pd=1.325 as=0.265 ps=2.53 w=1 l=0.15
X1 VPWR a_27_47# X VPB sky130_fd_pr__pfet_01v8_hvt ad=0.26 pd=2.52 as=0.135 ps=1.27 w=1 l=0.15 M=2
X2 VGND A a_27_47# VNB sky130_fd_pr__nfet_01v8 ad=0.06825 pd=0.745 as=0.1113 ps=1.37 w=0.42 l=0.15
X3 X a_27_47# VGND VNB sky130_fd_pr__nfet_01v8 ad=0.0567 pd=0.69 as=0.06825 ps=0.745 w=0.42 l=0.15 M=2
.ends

.subckt X2_sky130_fd_sc_hd__and4_1 X C A B D VGND VPWR VPB VNB
X0 a_27_47# C VPWR VPB sky130_fd_pr__pfet_01v8_hvt ad=0.0588 pd=0.7 as=0.0777 ps=0.79 w=0.42 l=0.15
X1 a_197_47# B a_109_47# VNB sky130_fd_pr__nfet_01v8 ad=0.0798 pd=0.8 as=0.0609 ps=0.71 w=0.42 l=0.15
X2 X a_27_47# VPWR VPB sky130_fd_pr__pfet_01v8_hvt ad=0.26 pd=2.52 as=0.31245 ps=1.68 w=1 l=0.15
X3 a_303_47# C a_197_47# VNB sky130_fd_pr__nfet_01v8 ad=0.0693 pd=0.75 as=0.0798 ps=0.8 w=0.42 l=0.15
X4 a_27_47# A VPWR VPB sky130_fd_pr__pfet_01v8_hvt ad=0.0735 pd=0.77 as=0.1092 ps=1.36 w=0.42 l=0.15
X5 VPWR D a_27_47# VPB sky130_fd_pr__pfet_01v8_hvt ad=0.31245 pd=1.68 as=0.0588 ps=0.7 w=0.42 l=0.15
X6 VGND D a_303_47# VNB sky130_fd_pr__nfet_01v8 ad=0.196275 pd=1.33 as=0.0693 ps=0.75 w=0.42 l=0.15
X7 VPWR B a_27_47# VPB sky130_fd_pr__pfet_01v8_hvt ad=0.0777 pd=0.79 as=0.0735 ps=0.77 w=0.42 l=0.15
X8 X a_27_47# VGND VNB sky130_fd_pr__nfet_01v8 ad=0.169 pd=1.82 as=0.196275 ps=1.33 w=0.65 l=0.15
X9 a_109_47# A a_27_47# VNB sky130_fd_pr__nfet_01v8 ad=0.0609 pd=0.71 as=0.1092 ps=1.36 w=0.42 l=0.15
.ends

.subckt X2_sky130_fd_sc_hd__and2_1 VPWR VGND X B A VPB VNB
X0 VPWR B a_59_75# VPB sky130_fd_pr__pfet_01v8_hvt ad=0.16655 pd=1.39 as=0.0567 ps=0.69 w=0.42 l=0.15
X1 X a_59_75# VPWR VPB sky130_fd_pr__pfet_01v8_hvt ad=0.475 pd=2.95 as=0.16655 ps=1.39 w=1 l=0.15
X2 VGND B a_145_75# VNB sky130_fd_pr__nfet_01v8 ad=0.1118 pd=1.04 as=0.0567 ps=0.69 w=0.42 l=0.15
X3 a_59_75# A VPWR VPB sky130_fd_pr__pfet_01v8_hvt ad=0.0567 pd=0.69 as=0.1176 ps=1.4 w=0.42 l=0.15
X4 X a_59_75# VGND VNB sky130_fd_pr__nfet_01v8 ad=0.182 pd=1.86 as=0.1118 ps=1.04 w=0.65 l=0.15
X5 a_145_75# A a_59_75# VNB sky130_fd_pr__nfet_01v8 ad=0.0567 pd=0.69 as=0.1176 ps=1.4 w=0.42 l=0.15
.ends

.subckt X2_sky130_fd_sc_hd__dlymetal6s2s_1 VPWR VGND VPB VNB X A
X0 a_558_47# a_381_47# VPWR VPB sky130_fd_pr__pfet_01v8_hvt ad=0.26 pd=2.52 as=0.14075 ps=1.325 w=1 l=0.15
X1 VGND X a_381_47# VNB sky130_fd_pr__nfet_01v8 ad=0.097 pd=0.975 as=0.1092 ps=1.36 w=0.42 l=0.15
X2 a_841_47# a_664_47# VPWR VPB sky130_fd_pr__pfet_01v8_hvt ad=0.26 pd=2.52 as=0.14075 ps=1.325 w=1 l=0.15
X3 VPWR A a_62_47# VPB sky130_fd_pr__pfet_01v8_hvt ad=0.14075 pd=1.325 as=0.1092 ps=1.36 w=0.42 l=0.15
X4 VGND A a_62_47# VNB sky130_fd_pr__nfet_01v8 ad=0.097 pd=0.975 as=0.1092 ps=1.36 w=0.42 l=0.15
X5 a_558_47# a_381_47# VGND VNB sky130_fd_pr__nfet_01v8 ad=0.169 pd=1.82 as=0.097 ps=0.975 w=0.65 l=0.15
X6 X a_62_47# VPWR VPB sky130_fd_pr__pfet_01v8_hvt ad=0.26 pd=2.52 as=0.14075 ps=1.325 w=1 l=0.15
X7 VPWR X a_381_47# VPB sky130_fd_pr__pfet_01v8_hvt ad=0.14075 pd=1.325 as=0.1092 ps=1.36 w=0.42 l=0.15
X8 a_841_47# a_664_47# VGND VNB sky130_fd_pr__nfet_01v8 ad=0.169 pd=1.82 as=0.097 ps=0.975 w=0.65 l=0.15
X9 X a_62_47# VGND VNB sky130_fd_pr__nfet_01v8 ad=0.169 pd=1.82 as=0.097 ps=0.975 w=0.65 l=0.15
X10 VPWR a_558_47# a_664_47# VPB sky130_fd_pr__pfet_01v8_hvt ad=0.14075 pd=1.325 as=0.1092 ps=1.36 w=0.42 l=0.15
X11 VGND a_558_47# a_664_47# VNB sky130_fd_pr__nfet_01v8 ad=0.097 pd=0.975 as=0.1092 ps=1.36 w=0.42 l=0.15
.ends

.subckt X2_sky130_fd_sc_hd__a21bo_1 VNB VPB VGND VPWR X A2 A1 B1_N
X0 a_298_297# a_27_413# a_215_297# VPB sky130_fd_pr__pfet_01v8_hvt ad=0.135 pd=1.27 as=0.265 ps=2.53 w=1 l=0.15
X1 a_215_297# a_27_413# VGND VNB sky130_fd_pr__nfet_01v8 ad=0.08775 pd=0.92 as=0.1359 ps=1.1 w=0.65 l=0.15
X2 a_298_297# A2 VPWR VPB sky130_fd_pr__pfet_01v8_hvt ad=0.265 pd=2.53 as=0.14 ps=1.28 w=1 l=0.15
X3 X a_215_297# VGND VNB sky130_fd_pr__nfet_01v8 ad=0.169 pd=1.82 as=0.258375 ps=1.445 w=0.65 l=0.15
X4 VPWR B1_N a_27_413# VPB sky130_fd_pr__pfet_01v8_hvt ad=0.1092 pd=1.36 as=0.1092 ps=1.36 w=0.42 l=0.15
X5 X a_215_297# VPWR VPB sky130_fd_pr__pfet_01v8_hvt ad=0.26 pd=2.52 as=0.26 ps=2.52 w=1 l=0.15
X6 a_382_47# A1 a_215_297# VNB sky130_fd_pr__nfet_01v8 ad=0.091 pd=0.93 as=0.08775 ps=0.92 w=0.65 l=0.15
X7 VGND B1_N a_27_413# VNB sky130_fd_pr__nfet_01v8 ad=0.1359 pd=1.1 as=0.1113 ps=1.37 w=0.42 l=0.15
X8 VPWR A1 a_298_297# VPB sky130_fd_pr__pfet_01v8_hvt ad=0.14 pd=1.28 as=0.135 ps=1.27 w=1 l=0.15
X9 VGND A2 a_382_47# VNB sky130_fd_pr__nfet_01v8 ad=0.258375 pd=1.445 as=0.091 ps=0.93 w=0.65 l=0.15
.ends

.subckt X2_sky130_fd_sc_hd__or3_1 VPWR VGND VPB VNB B C A X
X0 X a_29_53# VPWR VPB sky130_fd_pr__pfet_01v8_hvt ad=0.28 pd=2.56 as=0.14825 ps=1.34 w=1 l=0.15
X1 a_111_297# C a_29_53# VPB sky130_fd_pr__pfet_01v8_hvt ad=0.0441 pd=0.63 as=0.1092 ps=1.36 w=0.42 l=0.15
X2 X a_29_53# VGND VNB sky130_fd_pr__nfet_01v8 ad=0.182 pd=1.86 as=0.101875 ps=0.99 w=0.65 l=0.15
X3 a_183_297# B a_111_297# VPB sky130_fd_pr__pfet_01v8_hvt ad=0.0693 pd=0.75 as=0.0441 ps=0.63 w=0.42 l=0.15
X4 VPWR A a_183_297# VPB sky130_fd_pr__pfet_01v8_hvt ad=0.14825 pd=1.34 as=0.0693 ps=0.75 w=0.42 l=0.15
X5 a_29_53# B VGND VNB sky130_fd_pr__nfet_01v8 ad=0.0567 pd=0.69 as=0.0567 ps=0.69 w=0.42 l=0.15
X6 VGND C a_29_53# VNB sky130_fd_pr__nfet_01v8 ad=0.0567 pd=0.69 as=0.1092 ps=1.36 w=0.42 l=0.15
X7 VGND A a_29_53# VNB sky130_fd_pr__nfet_01v8 ad=0.101875 pd=0.99 as=0.0567 ps=0.69 w=0.42 l=0.15
.ends

.subckt X2_sky130_fd_sc_hd__nor2_2 VPB VNB VGND VPWR B Y A
X0 Y B a_27_297# VPB sky130_fd_pr__pfet_01v8_hvt ad=0.135 pd=1.27 as=0.135 ps=1.27 w=1 l=0.15 M=2
X1 Y B VGND VNB sky130_fd_pr__nfet_01v8 ad=0.08775 pd=0.92 as=0.08775 ps=0.92 w=0.65 l=0.15 M=2
X2 a_27_297# A VPWR VPB sky130_fd_pr__pfet_01v8_hvt ad=0.135 pd=1.27 as=0.135 ps=1.27 w=1 l=0.15 M=2
X3 VGND A Y VNB sky130_fd_pr__nfet_01v8 ad=0.08775 pd=0.92 as=0.08775 ps=0.92 w=0.65 l=0.15 M=2
.ends

.subckt X2_sky130_fd_sc_hd__a41oi_1 VGND VPWR A4 Y B1 A1 A2 A3 VPB VNB
X0 a_236_47# A4 VGND VNB sky130_fd_pr__nfet_01v8 ad=0.11375 pd=1 as=0.163425 ps=1.175 w=0.65 l=0.15
X1 a_428_47# A2 a_336_47# VNB sky130_fd_pr__nfet_01v8 ad=0.138125 pd=1.075 as=0.10075 ps=0.96 w=0.65 l=0.15
X2 a_109_297# A1 VPWR VPB sky130_fd_pr__pfet_01v8_hvt ad=0.37 pd=2.74 as=0.2125 ps=1.425 w=1 l=0.15
X3 Y A1 a_428_47# VNB sky130_fd_pr__nfet_01v8 ad=0.2405 pd=2.04 as=0.138125 ps=1.075 w=0.65 l=0.15
X4 a_336_47# A3 a_236_47# VNB sky130_fd_pr__nfet_01v8 ad=0.10075 pd=0.96 as=0.11375 ps=1 w=0.65 l=0.15
X5 VPWR A4 a_109_297# VPB sky130_fd_pr__pfet_01v8_hvt ad=0.205 pd=1.41 as=0.2125 ps=1.425 w=1 l=0.15
X6 a_109_297# B1 Y VPB sky130_fd_pr__pfet_01v8_hvt ad=0.2125 pd=1.425 as=0.26 ps=2.52 w=1 l=0.15
X7 a_109_297# A3 VPWR VPB sky130_fd_pr__pfet_01v8_hvt ad=0.155 pd=1.31 as=0.205 ps=1.41 w=1 l=0.15
X8 VPWR A2 a_109_297# VPB sky130_fd_pr__pfet_01v8_hvt ad=0.2125 pd=1.425 as=0.155 ps=1.31 w=1 l=0.15
X9 VGND B1 Y VNB sky130_fd_pr__nfet_01v8 ad=0.163425 pd=1.175 as=0.169 ps=1.82 w=0.65 l=0.15
.ends

.subckt X2_sky130_fd_sc_hd__or2_1 VPB VNB VGND VPWR X A B
X0 VGND A a_68_297# VNB sky130_fd_pr__nfet_01v8 ad=0.10025 pd=0.985 as=0.0567 ps=0.69 w=0.42 l=0.15
X1 a_68_297# B VGND VNB sky130_fd_pr__nfet_01v8 ad=0.0567 pd=0.69 as=0.1092 ps=1.36 w=0.42 l=0.15
X2 X a_68_297# VGND VNB sky130_fd_pr__nfet_01v8 ad=0.169 pd=1.82 as=0.10025 ps=0.985 w=0.65 l=0.15
X3 VPWR A a_150_297# VPB sky130_fd_pr__pfet_01v8_hvt ad=0.14575 pd=1.335 as=0.0441 ps=0.63 w=0.42 l=0.15
X4 X a_68_297# VPWR VPB sky130_fd_pr__pfet_01v8_hvt ad=0.34 pd=2.68 as=0.14575 ps=1.335 w=1 l=0.15
X5 a_150_297# B a_68_297# VPB sky130_fd_pr__pfet_01v8_hvt ad=0.0441 pd=0.63 as=0.1092 ps=1.36 w=0.42 l=0.15
.ends

.subckt X2_sky130_fd_sc_hd__clkbuf_4 VGND VPWR A X VPB VNB
X0 VPWR A a_27_47# VPB sky130_fd_pr__pfet_01v8_hvt ad=0.165 pd=1.33 as=0.265 ps=2.53 w=1 l=0.15
X1 VGND a_27_47# X VNB sky130_fd_pr__nfet_01v8 ad=0.1218 pd=1.42 as=0.0588 ps=0.7 w=0.42 l=0.15 M=4
X2 X a_27_47# VPWR VPB sky130_fd_pr__pfet_01v8_hvt ad=0.14 pd=1.28 as=0.14 ps=1.28 w=1 l=0.15 M=4
X3 VGND A a_27_47# VNB sky130_fd_pr__nfet_01v8 ad=0.07035 pd=0.755 as=0.1113 ps=1.37 w=0.42 l=0.15
.ends

.subckt X2_sky130_fd_sc_hd__and3_2 B X A C VPWR VGND VPB VNB
X0 VPWR a_29_311# X VPB sky130_fd_pr__pfet_01v8_hvt ad=0.26 pd=2.52 as=0.135 ps=1.27 w=1 l=0.15 M=2
X1 VPWR A a_29_311# VPB sky130_fd_pr__pfet_01v8_hvt ad=0.0567 pd=0.69 as=0.1092 ps=1.36 w=0.42 l=0.15
X2 VGND a_29_311# X VNB sky130_fd_pr__nfet_01v8 ad=0.17875 pd=1.85 as=0.08775 ps=0.92 w=0.65 l=0.15 M=2
X3 a_184_53# B a_112_53# VNB sky130_fd_pr__nfet_01v8 ad=0.05355 pd=0.675 as=0.0441 ps=0.63 w=0.42 l=0.15
X4 VPWR C a_29_311# VPB sky130_fd_pr__pfet_01v8_hvt ad=0.15075 pd=1.345 as=0.074375 ps=0.815 w=0.42 l=0.15
X5 a_112_53# A a_29_311# VNB sky130_fd_pr__nfet_01v8 ad=0.0441 pd=0.63 as=0.1092 ps=1.36 w=0.42 l=0.15
X6 a_29_311# B VPWR VPB sky130_fd_pr__pfet_01v8_hvt ad=0.074375 pd=0.815 as=0.0567 ps=0.69 w=0.42 l=0.15
X7 VGND C a_184_53# VNB sky130_fd_pr__nfet_01v8 ad=0.1304 pd=1.105 as=0.05355 ps=0.675 w=0.42 l=0.15
.ends

.subckt X2_sky130_fd_sc_hd__nand2_2 VPB VNB VGND VPWR Y A B
X0 VPWR A Y VPB sky130_fd_pr__pfet_01v8_hvt ad=0.26 pd=2.52 as=0.135 ps=1.27 w=1 l=0.15 M=2
X1 VPWR B Y VPB sky130_fd_pr__pfet_01v8_hvt ad=0.135 pd=1.27 as=0.135 ps=1.27 w=1 l=0.15 M=2
X2 a_27_47# B VGND VNB sky130_fd_pr__nfet_01v8 ad=0.08775 pd=0.92 as=0.08775 ps=0.92 w=0.65 l=0.15 M=2
X3 a_27_47# A Y VNB sky130_fd_pr__nfet_01v8 ad=0.169 pd=1.82 as=0.08775 ps=0.92 w=0.65 l=0.15 M=2
.ends

.subckt X2_sky130_fd_sc_hd__conb_1 LO HI VPB VNB VGND VPWR
X0 VPWR HI sky130_fd_pr__res_generic_po w=0.48 l=0.045
X1 LO VGND sky130_fd_pr__res_generic_po w=0.48 l=0.045
.ends

.subckt X2_sky130_fd_sc_hd__xor2_1 VNB VPB VPWR VGND A X B
X0 X a_35_297# a_285_297# VPB sky130_fd_pr__pfet_01v8_hvt ad=0.3 pd=2.6 as=0.26 ps=2.52 w=1 l=0.15
X1 X B a_285_47# VNB sky130_fd_pr__nfet_01v8 ad=0.25025 pd=1.42 as=0.08775 ps=0.92 w=0.65 l=0.15
X2 a_35_297# B VGND VNB sky130_fd_pr__nfet_01v8 ad=0.08775 pd=0.92 as=0.169 ps=1.82 w=0.65 l=0.15
X3 a_117_297# B a_35_297# VPB sky130_fd_pr__pfet_01v8_hvt ad=0.135 pd=1.27 as=0.26 ps=2.52 w=1 l=0.15
X4 VPWR B a_285_297# VPB sky130_fd_pr__pfet_01v8_hvt ad=0.26 pd=2.52 as=0.135 ps=1.27 w=1 l=0.15
X5 VGND A a_35_297# VNB sky130_fd_pr__nfet_01v8 ad=0.08775 pd=0.92 as=0.08775 ps=0.92 w=0.65 l=0.15
X6 VGND a_35_297# X VNB sky130_fd_pr__nfet_01v8 ad=0.208 pd=1.94 as=0.25025 ps=1.42 w=0.65 l=0.15
X7 a_285_297# A VPWR VPB sky130_fd_pr__pfet_01v8_hvt ad=0.135 pd=1.27 as=0.135 ps=1.27 w=1 l=0.15
X8 VPWR A a_117_297# VPB sky130_fd_pr__pfet_01v8_hvt ad=0.135 pd=1.27 as=0.135 ps=1.27 w=1 l=0.15
X9 a_285_47# A VGND VNB sky130_fd_pr__nfet_01v8 ad=0.08775 pd=0.92 as=0.08775 ps=0.92 w=0.65 l=0.15
.ends

.subckt X2_sky130_fd_sc_hd__nor3_2 VPB VNB VGND VPWR A B C Y
X0 Y C a_281_297# VPB sky130_fd_pr__pfet_01v8_hvt ad=0.135 pd=1.27 as=0.26 ps=2.52 w=1 l=0.15 M=2
X1 a_281_297# B a_27_297# VPB sky130_fd_pr__pfet_01v8_hvt ad=0.135 pd=1.27 as=0.135 ps=1.27 w=1 l=0.15 M=2
X2 Y B VGND VNB sky130_fd_pr__nfet_01v8 ad=0.08775 pd=0.92 as=0.08775 ps=0.92 w=0.65 l=0.15 M=2
X3 a_27_297# A VPWR VPB sky130_fd_pr__pfet_01v8_hvt ad=0.135 pd=1.27 as=0.135 ps=1.27 w=1 l=0.15 M=2
X4 VGND A Y VNB sky130_fd_pr__nfet_01v8 ad=0.08775 pd=0.92 as=0.08775 ps=0.92 w=0.65 l=0.15 M=2
X5 VGND C Y VNB sky130_fd_pr__nfet_01v8 ad=0.169 pd=1.82 as=0.08775 ps=0.92 w=0.65 l=0.15 M=2
.ends

.subckt X2_sky130_fd_sc_hd__xor2_2 VPWR VGND X B A VPB VNB
X0 a_27_297# A VPWR VPB sky130_fd_pr__pfet_01v8_hvt ad=0.135 pd=1.27 as=0.135 ps=1.27 w=1 l=0.15 M=2
X1 a_470_47# A VGND VNB sky130_fd_pr__nfet_01v8 ad=0.08775 pd=0.92 as=0.08775 ps=0.92 w=0.65 l=0.15 M=2
X2 a_470_297# A VPWR VPB sky130_fd_pr__pfet_01v8_hvt ad=0.135 pd=1.27 as=0.135 ps=1.27 w=1 l=0.15 M=2
X3 a_112_47# B VGND VNB sky130_fd_pr__nfet_01v8 ad=0.08775 pd=0.92 as=0.08775 ps=0.92 w=0.65 l=0.15 M=2
X4 a_470_47# B X VNB sky130_fd_pr__nfet_01v8 ad=0.169 pd=1.82 as=0.105625 ps=0.975 w=0.65 l=0.15 M=2
X5 VGND A a_112_47# VNB sky130_fd_pr__nfet_01v8 ad=0.08775 pd=0.92 as=0.08775 ps=0.92 w=0.65 l=0.15 M=2
X6 a_470_297# B VPWR VPB sky130_fd_pr__pfet_01v8_hvt ad=0.26 pd=2.52 as=0.1625 ps=1.325 w=1 l=0.15 M=2
X7 X a_112_47# VGND VNB sky130_fd_pr__nfet_01v8 ad=0.08775 pd=0.92 as=0.169 ps=1.82 w=0.65 l=0.15 M=2
X8 a_27_297# B a_112_47# VPB sky130_fd_pr__pfet_01v8_hvt ad=0.26 pd=2.52 as=0.135 ps=1.27 w=1 l=0.15 M=2
X9 X a_112_47# a_470_297# VPB sky130_fd_pr__pfet_01v8_hvt ad=0.135 pd=1.27 as=0.26 ps=2.52 w=1 l=0.15 M=2
.ends

.subckt X2_sky130_fd_sc_hd__nor3_1 VPB VNB VGND VPWR C B A Y
X0 VPWR A a_193_297# VPB sky130_fd_pr__pfet_01v8_hvt ad=0.26 pd=2.52 as=0.135 ps=1.27 w=1 l=0.15
X1 a_193_297# B a_109_297# VPB sky130_fd_pr__pfet_01v8_hvt ad=0.135 pd=1.27 as=0.135 ps=1.27 w=1 l=0.15
X2 Y B VGND VNB sky130_fd_pr__nfet_01v8 ad=0.08775 pd=0.92 as=0.08775 ps=0.92 w=0.65 l=0.15
X3 VGND A Y VNB sky130_fd_pr__nfet_01v8 ad=0.169 pd=1.82 as=0.08775 ps=0.92 w=0.65 l=0.15
X4 a_109_297# C Y VPB sky130_fd_pr__pfet_01v8_hvt ad=0.135 pd=1.27 as=0.26 ps=2.52 w=1 l=0.15
X5 VGND C Y VNB sky130_fd_pr__nfet_01v8 ad=0.08775 pd=0.92 as=0.169 ps=1.82 w=0.65 l=0.15
.ends

.subckt X2_sky130_fd_sc_hd__o21ba_1 VNB VPB VGND VPWR B1_N A1 A2 X
X0 a_222_93# B1_N VGND VNB sky130_fd_pr__nfet_01v8 ad=0.1092 pd=1.36 as=0.10025 ps=0.985 w=0.42 l=0.15
X1 VPWR A1 a_544_297# VPB sky130_fd_pr__pfet_01v8_hvt ad=0.28 pd=2.56 as=0.105 ps=1.21 w=1 l=0.15
X2 VGND a_79_199# X VNB sky130_fd_pr__nfet_01v8 ad=0.10025 pd=0.985 as=0.169 ps=1.82 w=0.65 l=0.15
X3 a_222_93# B1_N VPWR VPB sky130_fd_pr__pfet_01v8_hvt ad=0.1176 pd=1.4 as=0.18575 ps=1.415 w=0.42 l=0.15
X4 VGND A2 a_448_47# VNB sky130_fd_pr__nfet_01v8 ad=0.08775 pd=0.92 as=0.10725 ps=0.98 w=0.65 l=0.15
X5 a_448_47# a_222_93# a_79_199# VNB sky130_fd_pr__nfet_01v8 ad=0.10725 pd=0.98 as=0.169 ps=1.82 w=0.65 l=0.15
X6 a_79_199# a_222_93# VPWR VPB sky130_fd_pr__pfet_01v8_hvt ad=0.165 pd=1.33 as=0.3 ps=2.6 w=1 l=0.15
X7 a_544_297# A2 a_79_199# VPB sky130_fd_pr__pfet_01v8_hvt ad=0.105 pd=1.21 as=0.165 ps=1.33 w=1 l=0.15
X8 a_448_47# A1 VGND VNB sky130_fd_pr__nfet_01v8 ad=0.17225 pd=1.83 as=0.08775 ps=0.92 w=0.65 l=0.15
X9 VPWR a_79_199# X VPB sky130_fd_pr__pfet_01v8_hvt ad=0.18575 pd=1.415 as=0.26 ps=2.52 w=1 l=0.15
.ends

.subckt top_soc adc_data_in[0] adc_data_in[10] adc_data_in[11] adc_data_in[1] adc_data_in[2]
+ adc_data_in[3] adc_data_in[4] adc_data_in[5] adc_data_in[6] adc_data_in[7] adc_data_in[8]
+ adc_data_in[9] user_irq[0] user_irq[1] user_irq[2] vccd1 wb_clk_i wb_rst_i wbs_ack_o
+ wbs_adr_i[0] wbs_adr_i[10] wbs_adr_i[11] wbs_adr_i[12] wbs_adr_i[13] wbs_adr_i[14]
+ wbs_adr_i[15] wbs_adr_i[16] wbs_adr_i[17] wbs_adr_i[18] wbs_adr_i[19] wbs_adr_i[1]
+ wbs_adr_i[20] wbs_adr_i[21] wbs_adr_i[22] wbs_adr_i[23] wbs_adr_i[24] wbs_adr_i[25]
+ wbs_adr_i[26] wbs_adr_i[27] wbs_adr_i[28] wbs_adr_i[29] wbs_adr_i[2] wbs_adr_i[30]
+ wbs_adr_i[31] wbs_adr_i[3] wbs_adr_i[4] wbs_adr_i[5] wbs_adr_i[6] wbs_adr_i[7] wbs_adr_i[8]
+ wbs_adr_i[9] wbs_cyc_i wbs_dat_i[0] wbs_dat_i[10] wbs_dat_i[11] wbs_dat_i[12] wbs_dat_i[13]
+ wbs_dat_i[14] wbs_dat_i[15] wbs_dat_i[16] wbs_dat_i[17] wbs_dat_i[18] wbs_dat_i[19]
+ wbs_dat_i[1] wbs_dat_i[20] wbs_dat_i[21] wbs_dat_i[22] wbs_dat_i[23] wbs_dat_i[24]
+ wbs_dat_i[25] wbs_dat_i[26] wbs_dat_i[27] wbs_dat_i[28] wbs_dat_i[29] wbs_dat_i[2]
+ wbs_dat_i[30] wbs_dat_i[31] wbs_dat_i[3] wbs_dat_i[4] wbs_dat_i[5] wbs_dat_i[6]
+ wbs_dat_i[7] wbs_dat_i[8] wbs_dat_i[9] wbs_dat_o[0] wbs_dat_o[10] wbs_dat_o[11]
+ wbs_dat_o[12] wbs_dat_o[13] wbs_dat_o[14] wbs_dat_o[15] wbs_dat_o[16] wbs_dat_o[17]
+ wbs_dat_o[18] wbs_dat_o[19] wbs_dat_o[1] wbs_dat_o[20] wbs_dat_o[21] wbs_dat_o[22]
+ wbs_dat_o[23] wbs_dat_o[24] wbs_dat_o[25] wbs_dat_o[26] wbs_dat_o[27] wbs_dat_o[28]
+ wbs_dat_o[29] wbs_dat_o[2] wbs_dat_o[30] wbs_dat_o[31] wbs_dat_o[3] wbs_dat_o[4]
+ wbs_dat_o[5] wbs_dat_o[6] wbs_dat_o[7] wbs_dat_o[8] wbs_dat_o[9] wbs_sel_i[0] wbs_sel_i[1]
+ wbs_sel_i[2] wbs_sel_i[3] wbs_stb_i wbs_we_i vssd1
XANTENNA__283__A0 _449_/A1 vssd1 vccd1 vccd1 vssd1 X2_sky130_fd_sc_hd__diode_2
XFILLER_79_391 vccd1 vssd1 vccd1 vssd1 X2_sky130_fd_sc_hd__fill_1
XFILLER_67_553 vssd1 vccd1 vccd1 vssd1 X2_sky130_fd_sc_hd__fill_4
XFILLER_27_417 vssd1 vccd1 vssd1 vccd1 X2_sky130_ef_sc_hd__decap_40_12
XFILLER_94_361 vssd1 vccd1 vccd1 vssd1 X2_sky130_fd_sc_hd__fill_2
XFILLER_82_501 vssd1 vccd1 vssd1 vccd1 X2_sky130_ef_sc_hd__decap_40_12
XFILLER_39_288 vssd1 vccd1 vccd1 vssd1 X2_sky130_fd_sc_hd__fill_2
XFILLER_82_545 vssd1 vccd1 vssd1 vccd1 X2_sky130_ef_sc_hd__decap_40_12
XFILLER_35_461 vssd1 vccd1 vccd1 vssd1 X2_sky130_fd_sc_hd__fill_2
XFILLER_82_589 vssd1 vccd1 vssd1 vccd1 X2_sky130_ef_sc_hd__decap_40_12
XFILLER_22_133 vssd1 vccd1 vccd1 vssd1 X2_sky130_fd_sc_hd__fill_4
XFILLER_52_29 vssd1 vccd1 vssd1 vccd1 X2_sky130_ef_sc_hd__decap_40_12
XFILLER_50_475 vccd1 vssd1 vccd1 vssd1 X2_sky130_fd_sc_hd__fill_1
XFILLER_22_177 vssd1 vccd1 vssd1 vccd1 X2_sky130_ef_sc_hd__decap_40_12
XFILLER_89_111 vccd1 vssd1 vccd1 vssd1 X2_sky130_fd_sc_hd__fill_1
XFILLER_77_15 vssd1 vccd1 vssd1 vccd1 X2_sky130_ef_sc_hd__decap_40_12
XFILLER_77_317 vssd1 vccd1 vssd1 vccd1 X2_sky130_ef_sc_hd__decap_40_12
XFILLER_58_531 vccd1 vssd1 vccd1 vssd1 X2_sky130_fd_sc_hd__fill_1
XFILLER_18_417 vssd1 vccd1 vccd1 vssd1 X2_sky130_fd_sc_hd__fill_2
XFILLER_92_309 vssd1 vccd1 vccd1 vssd1 X2_sky130_fd_sc_hd__fill_8
XFILLER_85_361 vssd1 vccd1 vssd1 vccd1 X2_sky130_ef_sc_hd__decap_40_12
XFILLER_73_501 vssd1 vccd1 vccd1 vssd1 X2_sky130_fd_sc_hd__fill_2
XFILLER_58_597 vssd1 vccd1 vccd1 vssd1 X2_sky130_fd_sc_hd__fill_2
XFILLER_45_225 vccd1 vssd1 vccd1 vssd1 X2_sky130_fd_sc_hd__fill_1
XFILLER_26_41 vssd1 vccd1 vssd1 vccd1 X2_sky130_ef_sc_hd__decap_40_12
XFILLER_93_69 vssd1 vccd1 vssd1 vccd1 X2_sky130_ef_sc_hd__decap_40_12
X_501_ vccd1 vssd1 vccd1 vssd1 _501_/Y _517_/A X2_sky130_fd_sc_hd__inv_2
XFILLER_14_601 vssd1 vccd1 vssd1 vccd1 X2_sky130_ef_sc_hd__decap_40_12
X_432_ vssd1 vccd1 _553_/D _431_/X _552_/D _433_/C _556_/D _551_/D vccd1 vssd1 X2_sky130_fd_sc_hd__a41o_1
XFILLER_13_111 vccd1 vssd1 vccd1 vssd1 X2_sky130_fd_sc_hd__fill_1
XFILLER_26_85 vssd1 vccd1 vssd1 vccd1 X2_sky130_ef_sc_hd__decap_40_12
X_363_ vssd1 vccd1 vssd1 vccd1 _549_/Q _393_/C _534_/Q X2_sky130_fd_sc_hd__nand2b_2
XFILLER_41_464 vssd1 vccd1 vssd1 vccd1 X2_sky130_ef_sc_hd__decap_40_12
XFILLER_9_137 vssd1 vccd1 vssd1 vccd1 X2_sky130_ef_sc_hd__decap_40_12
XANTENNA__329__B2 _534_/Q vssd1 vccd1 vccd1 vssd1 X2_sky130_fd_sc_hd__diode_2
X_294_ vssd1 vccd1 vccd1 vssd1 _579_/D hold70/X _299_/S _448_/A1 X2_sky130_fd_sc_hd__mux2_1
XTAP_TAPCELL_ROW_11_345 vccd1 vssd1 X2_sky130_fd_sc_hd__tapvpwrvgnd_1
XTAP_TAPCELL_ROW_97_1288 vccd1 vssd1 X2_sky130_fd_sc_hd__tapvpwrvgnd_1
XFILLER_68_317 vccd1 vssd1 vccd1 vssd1 X2_sky130_fd_sc_hd__fill_1
XFILLER_95_125 vssd1 vccd1 vssd1 vccd1 X2_sky130_ef_sc_hd__decap_40_12
XFILLER_49_520 vssd1 vccd1 vssd1 vccd1 X2_sky130_ef_sc_hd__decap_40_12
XFILLER_95_169 vssd1 vccd1 vssd1 vccd1 X2_sky130_ef_sc_hd__decap_40_12
XFILLER_76_361 vssd1 vccd1 vccd1 vssd1 X2_sky130_fd_sc_hd__fill_2
XFILLER_67_81 vssd1 vccd1 vssd1 vccd1 X2_sky130_ef_sc_hd__decap_40_12
XTAP_TAPCELL_ROW_47_732 vccd1 vssd1 X2_sky130_fd_sc_hd__tapvpwrvgnd_1
XTAP_TAPCELL_ROW_19_434 vccd1 vssd1 X2_sky130_fd_sc_hd__tapvpwrvgnd_1
XFILLER_64_545 vssd1 vccd1 vssd1 vccd1 X2_sky130_ef_sc_hd__decap_40_12
XFILLER_17_461 vssd1 vccd1 vssd1 vccd1 X2_sky130_ef_sc_hd__decap_40_12
XFILLER_91_364 vssd1 vccd1 vssd1 vccd1 X2_sky130_ef_sc_hd__decap_40_12
XFILLER_64_589 vccd1 vssd1 vccd1 vssd1 X2_sky130_fd_sc_hd__fill_1
XANTENNA__275__S _289_/S vssd1 vccd1 vccd1 vssd1 X2_sky130_fd_sc_hd__diode_2
XFILLER_32_464 vssd1 vccd1 vssd1 vccd1 X2_sky130_ef_sc_hd__decap_40_12
XANTENNA__304__A _304_/A vssd1 vccd1 vccd1 vssd1 X2_sky130_fd_sc_hd__diode_2
XTAP_TAPCELL_ROW_74_1030 vccd1 vssd1 X2_sky130_fd_sc_hd__tapvpwrvgnd_1
XFILLER_87_615 vccd1 vssd1 vccd1 vssd1 X2_sky130_fd_sc_hd__fill_1
XFILLER_99_497 vssd1 vccd1 vccd1 vssd1 X2_sky130_fd_sc_hd__fill_4
XFILLER_74_309 vssd1 vccd1 vssd1 vccd1 X2_sky130_ef_sc_hd__decap_40_12
XFILLER_67_361 vssd1 vccd1 vssd1 vccd1 X2_sky130_ef_sc_hd__decap_40_12
XFILLER_55_501 vssd1 vccd1 vccd1 vssd1 X2_sky130_fd_sc_hd__fill_2
XFILLER_27_225 vssd1 vccd1 vssd1 vccd1 X2_sky130_ef_sc_hd__decap_40_12
XFILLER_63_39 vssd1 vccd1 vssd1 vccd1 X2_sky130_ef_sc_hd__decap_40_12
XFILLER_55_578 vssd1 vccd1 vssd1 vccd1 X2_sky130_ef_sc_hd__decap_40_12
XFILLER_42_217 vssd1 vccd1 vssd1 vccd1 X2_sky130_ef_sc_hd__decap_40_12
XFILLER_11_615 vccd1 vssd1 vccd1 vssd1 X2_sky130_fd_sc_hd__fill_1
XFILLER_23_497 vssd1 vccd1 vccd1 vssd1 X2_sky130_fd_sc_hd__fill_4
XFILLER_50_294 vssd1 vccd1 vssd1 vccd1 X2_sky130_ef_sc_hd__decap_40_12
XFILLER_12_65 vssd1 vccd1 vssd1 vccd1 X2_sky130_ef_sc_hd__decap_40_12
XFILLER_2_357 vssd1 vccd1 vccd1 vssd1 X2_sky130_fd_sc_hd__fill_4
XFILLER_77_125 vssd1 vccd1 vssd1 vccd1 X2_sky130_ef_sc_hd__decap_40_12
XFILLER_77_169 vssd1 vccd1 vssd1 vccd1 X2_sky130_ef_sc_hd__decap_40_12
XFILLER_46_501 vssd1 vccd1 vssd1 vccd1 X2_sky130_ef_sc_hd__decap_40_12
XFILLER_37_51 vssd1 vccd1 vccd1 vssd1 X2_sky130_fd_sc_hd__fill_4
XFILLER_92_139 vccd1 vssd1 vccd1 vssd1 X2_sky130_fd_sc_hd__fill_1
XFILLER_58_361 vssd1 vccd1 vccd1 vssd1 X2_sky130_fd_sc_hd__fill_2
XFILLER_46_589 vssd1 vccd1 vccd1 vssd1 X2_sky130_fd_sc_hd__fill_8
XTAP_TAPCELL_ROW_44_702 vccd1 vssd1 X2_sky130_fd_sc_hd__tapvpwrvgnd_1
XFILLER_61_559 vccd1 vssd1 vccd1 vssd1 X2_sky130_fd_sc_hd__fill_1
X_415_ vssd1 vccd1 vssd1 vccd1 _415_/X _379_/X _411_/Y _413_/Y _414_/Y X2_sky130_fd_sc_hd__o211a_1
XFILLER_14_475 vccd1 vssd1 vccd1 vssd1 X2_sky130_fd_sc_hd__fill_1
XTAP_TAPCELL_ROW_24_481 vccd1 vssd1 X2_sky130_fd_sc_hd__tapvpwrvgnd_1
XTAP_TAPCELL_ROW_99_1306 vccd1 vssd1 X2_sky130_fd_sc_hd__tapvpwrvgnd_1
XTAP_TAPCELL_ROW_52_790 vccd1 vssd1 X2_sky130_fd_sc_hd__tapvpwrvgnd_1
X_346_ vccd1 vssd1 vccd1 vssd1 _582_/Q _584_/Q _585_/Q _583_/Q _347_/B X2_sky130_fd_sc_hd__or4_1
X_277_ vssd1 vccd1 vccd1 vssd1 _602_/D hold13/X _289_/S _277_/A0 X2_sky130_fd_sc_hd__mux2_1
XFILLER_96_445 vssd1 vccd1 vssd1 vccd1 X2_sky130_ef_sc_hd__decap_40_12
XFILLER_1_390 vssd1 vccd1 vccd1 vssd1 X2_sky130_fd_sc_hd__fill_2
XFILLER_96_489 vssd1 vccd1 vssd1 vccd1 X2_sky130_ef_sc_hd__decap_40_12
XFILLER_56_309 vssd1 vccd1 vssd1 vccd1 X2_sky130_ef_sc_hd__decap_40_12
XFILLER_49_350 vssd1 vccd1 vccd1 vssd1 X2_sky130_fd_sc_hd__fill_2
XFILLER_37_501 vssd1 vccd1 vccd1 vssd1 X2_sky130_fd_sc_hd__fill_2
XFILLER_37_545 vssd1 vccd1 vccd1 vssd1 X2_sky130_fd_sc_hd__fill_2
XFILLER_37_589 vssd1 vccd1 vccd1 vssd1 X2_sky130_fd_sc_hd__fill_4
XFILLER_91_161 vssd1 vccd1 vccd1 vssd1 X2_sky130_fd_sc_hd__fill_4
XFILLER_52_526 vssd1 vccd1 vccd1 vssd1 X2_sky130_fd_sc_hd__fill_4
XFILLER_20_401 vssd1 vccd1 vssd1 vccd1 X2_sky130_ef_sc_hd__decap_40_12
XFILLER_60_581 vssd1 vccd1 vccd1 vssd1 X2_sky130_fd_sc_hd__fill_4
XFILLER_20_445 vssd1 vccd1 vssd1 vccd1 X2_sky130_ef_sc_hd__decap_40_12
XFILLER_20_489 vssd1 vccd1 vssd1 vccd1 X2_sky130_ef_sc_hd__decap_40_12
XFILLER_99_261 vssd1 vccd1 vssd1 vccd1 X2_sky130_ef_sc_hd__decap_40_12
XFILLER_87_445 vssd1 vccd1 vccd1 vssd1 X2_sky130_fd_sc_hd__fill_2
XFILLER_101_222 vssd1 vccd1 vccd1 vssd1 X2_sky130_fd_sc_hd__fill_2
XFILLER_99_283 vccd1 vssd1 vccd1 vssd1 X2_sky130_fd_sc_hd__fill_1
XFILLER_59_125 vssd1 vccd1 vssd1 vccd1 X2_sky130_ef_sc_hd__decap_40_12
XFILLER_101_266 vssd1 vccd1 vccd1 vssd1 X2_sky130_fd_sc_hd__fill_2
XFILLER_59_169 vssd1 vccd1 vssd1 vccd1 X2_sky130_ef_sc_hd__decap_40_12
XFILLER_28_501 vssd1 vccd1 vssd1 vccd1 X2_sky130_ef_sc_hd__decap_40_12
XFILLER_74_139 vccd1 vssd1 vccd1 vssd1 X2_sky130_fd_sc_hd__fill_1
XFILLER_28_545 vssd1 vccd1 vssd1 vccd1 X2_sky130_ef_sc_hd__decap_40_12
XFILLER_74_27 vccd1 vssd1 vccd1 vssd1 X2_sky130_fd_sc_hd__fill_1
XFILLER_55_320 vssd1 vccd1 vssd1 vccd1 X2_sky130_ef_sc_hd__decap_40_12
XFILLER_15_217 vssd1 vccd1 vccd1 vssd1 X2_sky130_fd_sc_hd__fill_4
XFILLER_28_589 vssd1 vccd1 vssd1 vccd1 X2_sky130_ef_sc_hd__decap_40_12
XFILLER_70_301 vssd1 vccd1 vccd1 vssd1 X2_sky130_fd_sc_hd__fill_4
XTAP_TAPCELL_ROW_83_1129 vccd1 vssd1 X2_sky130_fd_sc_hd__tapvpwrvgnd_1
XFILLER_70_345 vssd1 vccd1 vssd1 vccd1 X2_sky130_ef_sc_hd__decap_40_12
XFILLER_43_559 vccd1 vssd1 vccd1 vssd1 X2_sky130_fd_sc_hd__fill_1
XFILLER_30_209 vssd1 vccd1 vssd1 vccd1 X2_sky130_ef_sc_hd__decap_40_12
XFILLER_90_15 vssd1 vccd1 vssd1 vccd1 X2_sky130_ef_sc_hd__decap_40_12
XFILLER_23_261 vssd1 vccd1 vssd1 vccd1 X2_sky130_ef_sc_hd__decap_40_12
XFILLER_70_389 vssd1 vccd1 vssd1 vccd1 X2_sky130_ef_sc_hd__decap_40_12
XFILLER_7_405 vssd1 vccd1 vssd1 vccd1 X2_sky130_ef_sc_hd__decap_40_12
XFILLER_11_445 vssd1 vccd1 vccd1 vssd1 X2_sky130_fd_sc_hd__fill_2
XFILLER_7_449 vssd1 vccd1 vssd1 vccd1 X2_sky130_ef_sc_hd__decap_40_12
XTAP_TAPCELL_ROW_21_451 vccd1 vssd1 X2_sky130_fd_sc_hd__tapvpwrvgnd_1
XFILLER_99_57 vssd1 vccd1 vssd1 vccd1 X2_sky130_ef_sc_hd__decap_40_12
XFILLER_2_121 vssd1 vccd1 vssd1 vccd1 X2_sky130_ef_sc_hd__decap_40_12
XTAP_TAPCELL_ROW_94_1258 vccd1 vssd1 X2_sky130_fd_sc_hd__tapvpwrvgnd_1
XFILLER_2_165 vssd1 vccd1 vssd1 vccd1 X2_sky130_ef_sc_hd__decap_40_12
XFILLER_78_401 vssd1 vccd1 vssd1 vccd1 X2_sky130_ef_sc_hd__decap_40_12
XFILLER_78_445 vssd1 vccd1 vssd1 vccd1 X2_sky130_ef_sc_hd__decap_40_12
XFILLER_38_309 vssd1 vccd1 vccd1 vssd1 X2_sky130_fd_sc_hd__fill_4
XFILLER_66_618 vssd1 vccd1 vccd1 vssd1 X2_sky130_fd_sc_hd__fill_2
XFILLER_19_501 vssd1 vccd1 vccd1 vssd1 X2_sky130_fd_sc_hd__fill_2
XFILLER_78_489 vssd1 vccd1 vssd1 vccd1 X2_sky130_ef_sc_hd__decap_40_12
XFILLER_48_83 vccd1 vssd1 vccd1 vssd1 X2_sky130_fd_sc_hd__fill_1
XFILLER_46_342 vssd1 vccd1 vssd1 vccd1 X2_sky130_ef_sc_hd__decap_40_12
XFILLER_0_57 vssd1 vccd1 vssd1 vccd1 X2_sky130_ef_sc_hd__decap_40_12
XTAP_TAPCELL_ROW_29_540 vccd1 vssd1 X2_sky130_fd_sc_hd__tapvpwrvgnd_1
XFILLER_34_515 vssd1 vccd1 vccd1 vssd1 X2_sky130_fd_sc_hd__fill_2
XFILLER_80_109 vssd1 vccd1 vssd1 vccd1 X2_sky130_ef_sc_hd__decap_40_12
XFILLER_73_161 vssd1 vccd1 vccd1 vssd1 X2_sky130_fd_sc_hd__fill_4
XFILLER_61_345 vssd1 vccd1 vccd1 vssd1 X2_sky130_fd_sc_hd__fill_2
XFILLER_46_397 vccd1 vssd1 vccd1 vssd1 X2_sky130_fd_sc_hd__fill_1
XFILLER_9_55 vccd1 vssd1 vccd1 vssd1 X2_sky130_fd_sc_hd__fill_1
X_329_ vccd1 vssd1 vccd1 vssd1 _578_/Q _291_/B _329_/X _310_/Y _534_/Q _303_/X X2_sky130_fd_sc_hd__a221o_1
XFILLER_80_81 vssd1 vccd1 vccd1 vssd1 X2_sky130_fd_sc_hd__fill_2
XFILLER_50_3 vssd1 vccd1 vssd1 vccd1 X2_sky130_ef_sc_hd__decap_40_12
XFILLER_88_209 vssd1 vccd1 vssd1 vccd1 X2_sky130_ef_sc_hd__decap_40_12
XTAP_TAPCELL_ROW_71_1000 vccd1 vssd1 X2_sky130_fd_sc_hd__tapvpwrvgnd_1
XFILLER_69_445 vssd1 vccd1 vccd1 vssd1 X2_sky130_fd_sc_hd__fill_2
XFILLER_96_253 vssd1 vccd1 vssd1 vccd1 X2_sky130_ef_sc_hd__decap_40_12
XFILLER_56_139 vccd1 vssd1 vccd1 vssd1 X2_sky130_fd_sc_hd__fill_1
XFILLER_37_364 vccd1 vssd1 vccd1 vssd1 X2_sky130_fd_sc_hd__fill_1
XFILLER_71_109 vssd1 vccd1 vccd1 vssd1 X2_sky130_fd_sc_hd__fill_2
XFILLER_25_559 vccd1 vssd1 vccd1 vssd1 X2_sky130_fd_sc_hd__fill_1
XFILLER_12_209 vssd1 vccd1 vssd1 vccd1 X2_sky130_ef_sc_hd__decap_40_12
XFILLER_40_529 vssd1 vccd1 vccd1 vssd1 X2_sky130_fd_sc_hd__fill_2
XFILLER_20_253 vssd1 vccd1 vssd1 vccd1 X2_sky130_ef_sc_hd__decap_40_12
XFILLER_60_29 vssd1 vccd1 vssd1 vccd1 X2_sky130_ef_sc_hd__decap_40_12
XFILLER_4_419 vccd1 vssd1 vccd1 vssd1 X2_sky130_fd_sc_hd__fill_1
XFILLER_69_27 vssd1 vccd1 vssd1 vccd1 X2_sky130_ef_sc_hd__decap_40_12
XFILLER_85_15 vssd1 vccd1 vssd1 vccd1 X2_sky130_ef_sc_hd__decap_40_12
XFILLER_18_53 vssd1 vccd1 vssd1 vccd1 X2_sky130_ef_sc_hd__decap_40_12
XFILLER_62_109 vssd1 vccd1 vssd1 vccd1 X2_sky130_ef_sc_hd__decap_40_12
XFILLER_55_161 vssd1 vccd1 vccd1 vssd1 X2_sky130_fd_sc_hd__fill_4
XFILLER_18_97 vssd1 vccd1 vssd1 vccd1 X2_sky130_ef_sc_hd__decap_40_12
XTAP_TAPCELL_ROW_26_510 vccd1 vssd1 X2_sky130_fd_sc_hd__tapvpwrvgnd_1
XFILLER_70_153 vssd1 vccd1 vssd1 vccd1 X2_sky130_ef_sc_hd__decap_40_12
XFILLER_43_356 vssd1 vccd1 vssd1 vccd1 X2_sky130_ef_sc_hd__decap_40_12
XFILLER_24_581 vssd1 vccd1 vccd1 vssd1 X2_sky130_fd_sc_hd__fill_4
XFILLER_31_529 vssd1 vccd1 vssd1 vccd1 X2_sky130_ef_sc_hd__decap_40_12
XFILLER_34_41 vssd1 vccd1 vssd1 vccd1 X2_sky130_ef_sc_hd__decap_40_12
XFILLER_43_378 vccd1 vssd1 vccd1 vssd1 X2_sky130_fd_sc_hd__fill_1
XFILLER_34_85 vssd1 vccd1 vssd1 vccd1 X2_sky130_ef_sc_hd__decap_40_12
XFILLER_70_197 vssd1 vccd1 vssd1 vccd1 X2_sky130_ef_sc_hd__decap_40_12
XFILLER_7_279 vccd1 vssd1 vccd1 vssd1 X2_sky130_fd_sc_hd__fill_1
XFILLER_3_441 vssd1 vccd1 vccd1 vssd1 X2_sky130_fd_sc_hd__fill_4
XFILLER_98_529 vssd1 vccd1 vccd1 vssd1 X2_sky130_fd_sc_hd__fill_2
XFILLER_3_485 vssd1 vccd1 vssd1 vccd1 X2_sky130_ef_sc_hd__decap_40_12
XFILLER_78_253 vssd1 vccd1 vssd1 vccd1 X2_sky130_ef_sc_hd__decap_40_12
XFILLER_59_93 vssd1 vccd1 vssd1 vccd1 X2_sky130_ef_sc_hd__decap_40_12
XTAP_TAPCELL_ROW_6_290 vccd1 vssd1 X2_sky130_fd_sc_hd__tapvpwrvgnd_1
XFILLER_38_139 vccd1 vssd1 vccd1 vssd1 X2_sky130_fd_sc_hd__fill_1
XFILLER_93_223 vccd1 vssd1 vccd1 vssd1 X2_sky130_fd_sc_hd__fill_1
XFILLER_93_278 vssd1 vccd1 vccd1 vssd1 X2_sky130_fd_sc_hd__fill_2
XFILLER_81_429 vssd1 vccd1 vssd1 vccd1 X2_sky130_ef_sc_hd__decap_40_12
XFILLER_75_81 vssd1 vccd1 vssd1 vccd1 X2_sky130_ef_sc_hd__decap_40_12
XFILLER_53_109 vssd1 vccd1 vccd1 vssd1 X2_sky130_fd_sc_hd__fill_2
XFILLER_34_334 vccd1 vssd1 vccd1 vssd1 X2_sky130_fd_sc_hd__fill_1
XFILLER_22_529 vssd1 vccd1 vccd1 vssd1 X2_sky130_fd_sc_hd__fill_2
XFILLER_98_3 vssd1 vccd1 vssd1 vccd1 X2_sky130_ef_sc_hd__decap_40_12
XANTENNA__283__S _289_/S vssd1 vccd1 vccd1 vssd1 X2_sky130_fd_sc_hd__diode_2
XTAP_TAPCELL_ROW_32_568 vccd1 vssd1 X2_sky130_fd_sc_hd__tapvpwrvgnd_1
XTAP_TAPCELL_ROW_60_877 vccd1 vssd1 X2_sky130_fd_sc_hd__tapvpwrvgnd_1
XFILLER_89_529 vssd1 vccd1 vssd1 vccd1 X2_sky130_ef_sc_hd__decap_40_12
XFILLER_97_573 vssd1 vccd1 vssd1 vccd1 X2_sky130_ef_sc_hd__decap_40_12
XFILLER_84_245 vssd1 vccd1 vccd1 vssd1 X2_sky130_fd_sc_hd__fill_4
XTAP_TAPCELL_ROW_68_966 vccd1 vssd1 X2_sky130_fd_sc_hd__tapvpwrvgnd_1
XFILLER_44_109 vssd1 vccd1 vssd1 vccd1 X2_sky130_ef_sc_hd__decap_40_12
XFILLER_37_161 vssd1 vccd1 vccd1 vssd1 X2_sky130_fd_sc_hd__fill_4
XFILLER_53_621 vccd1 vssd1 vccd1 vssd1 X2_sky130_fd_sc_hd__fill_1
XFILLER_52_153 vssd1 vccd1 vssd1 vccd1 X2_sky130_ef_sc_hd__decap_40_12
XFILLER_13_529 vssd1 vccd1 vssd1 vccd1 X2_sky130_ef_sc_hd__decap_40_12
XFILLER_25_389 vssd1 vccd1 vccd1 vssd1 X2_sky130_fd_sc_hd__fill_2
XFILLER_80_473 vssd1 vccd1 vccd1 vssd1 X2_sky130_fd_sc_hd__fill_2
XFILLER_71_39 vssd1 vccd1 vssd1 vccd1 X2_sky130_ef_sc_hd__decap_40_12
XFILLER_52_197 vccd1 vssd1 vccd1 vssd1 X2_sky130_fd_sc_hd__fill_1
XFILLER_21_573 vssd1 vccd1 vssd1 vccd1 X2_sky130_ef_sc_hd__decap_40_12
XFILLER_4_249 vssd1 vccd1 vccd1 vssd1 X2_sky130_fd_sc_hd__fill_2
XFILLER_20_65 vssd1 vccd1 vssd1 vccd1 X2_sky130_ef_sc_hd__decap_40_12
XTAP_TAPCELL_ROW_91_1217 vccd1 vssd1 X2_sky130_fd_sc_hd__tapvpwrvgnd_1
XFILLER_0_433 vssd1 vccd1 vssd1 vccd1 X2_sky130_ef_sc_hd__decap_40_12
XFILLER_0_477 vssd1 vccd1 vssd1 vccd1 X2_sky130_ef_sc_hd__decap_40_12
Xhold30 hold30/X _566_/Q vccd1 vssd1 vssd1 vccd1 X2_sky130_fd_sc_hd__dlygate4sd3_1
Xhold41 _554_/D _539_/Q vccd1 vssd1 vssd1 vccd1 X2_sky130_fd_sc_hd__dlygate4sd3_1
XANTENNA_fanout60_X _473_/A vssd1 vccd1 vccd1 vssd1 X2_sky130_fd_sc_hd__diode_2
Xhold74 hold74/X _580_/Q vccd1 vssd1 vssd1 vccd1 X2_sky130_fd_sc_hd__dlygate4sd3_1
XFILLER_75_223 vccd1 vssd1 vccd1 vssd1 X2_sky130_fd_sc_hd__fill_1
Xhold63 hold63/X _573_/Q vccd1 vssd1 vssd1 vccd1 X2_sky130_fd_sc_hd__dlygate4sd3_1
Xhold52 hold52/X _589_/Q vccd1 vssd1 vssd1 vccd1 X2_sky130_fd_sc_hd__dlygate4sd3_1
XFILLER_35_109 vssd1 vccd1 vccd1 vssd1 X2_sky130_fd_sc_hd__fill_2
Xhold85 hold85/X _554_/Q vccd1 vssd1 vssd1 vccd1 X2_sky130_fd_sc_hd__dlygate4sd3_1
XANTENNA_input18_A wbs_adr_i[4] vssd1 vccd1 vccd1 vssd1 X2_sky130_fd_sc_hd__diode_2
XFILLER_16_301 vssd1 vccd1 vccd1 vssd1 X2_sky130_fd_sc_hd__fill_4
XFILLER_63_429 vssd1 vccd1 vssd1 vccd1 X2_sky130_ef_sc_hd__decap_40_12
XFILLER_16_345 vssd1 vccd1 vssd1 vccd1 X2_sky130_ef_sc_hd__decap_40_12
X_594_ vccd1 vssd1 vccd1 vssd1 _594_/Q _514_/Y _594_/D _597_/CLK X2_sky130_fd_sc_hd__dfstp_1
Xclkbuf_3_7__f_wb_clk_i vssd1 vccd1 vssd1 vccd1 clkbuf_0_wb_clk_i/X _606_/CLK X2_sky130_fd_sc_hd__clkbuf_16
XFILLER_45_51 vssd1 vccd1 vccd1 vssd1 X2_sky130_fd_sc_hd__fill_4
XFILLER_16_389 vssd1 vccd1 vssd1 vccd1 X2_sky130_ef_sc_hd__decap_40_12
XFILLER_71_473 vssd1 vccd1 vssd1 vccd1 X2_sky130_ef_sc_hd__decap_40_12
XFILLER_31_337 vssd1 vccd1 vccd1 vssd1 X2_sky130_fd_sc_hd__fill_8
XTAP_TAPCELL_ROW_100_1324 vccd1 vssd1 X2_sky130_fd_sc_hd__tapvpwrvgnd_1
XFILLER_8_533 vssd1 vccd1 vssd1 vccd1 X2_sky130_ef_sc_hd__decap_40_12
XFILLER_3_293 vssd1 vccd1 vssd1 vccd1 X2_sky130_ef_sc_hd__decap_40_12
XFILLER_100_309 vssd1 vccd1 vccd1 vssd1 X2_sky130_fd_sc_hd__fill_4
XFILLER_79_573 vssd1 vccd1 vssd1 vccd1 X2_sky130_ef_sc_hd__decap_40_12
XFILLER_13_3 vssd1 vccd1 vssd1 vccd1 X2_sky130_ef_sc_hd__decap_40_12
XFILLER_66_245 vssd1 vccd1 vccd1 vssd1 X2_sky130_fd_sc_hd__fill_4
XFILLER_26_109 vssd1 vccd1 vssd1 vccd1 X2_sky130_ef_sc_hd__decap_40_12
XANTENNA__278__S _289_/S vssd1 vccd1 vccd1 vssd1 X2_sky130_fd_sc_hd__diode_2
XFILLER_94_587 vccd1 vssd1 vccd1 vssd1 X2_sky130_fd_sc_hd__fill_1
XFILLER_19_161 vssd1 vccd1 vccd1 vssd1 X2_sky130_fd_sc_hd__fill_4
XTAP_TAPCELL_ROW_37_627 vccd1 vssd1 X2_sky130_fd_sc_hd__tapvpwrvgnd_1
XFILLER_81_237 vssd1 vccd1 vssd1 vccd1 X2_sky130_ef_sc_hd__decap_40_12
XFILLER_66_289 vssd1 vccd1 vssd1 vccd1 X2_sky130_ef_sc_hd__decap_40_12
XTAP_TAPCELL_ROW_65_936 vccd1 vssd1 X2_sky130_fd_sc_hd__tapvpwrvgnd_1
XFILLER_54_429 vssd1 vccd1 vccd1 vssd1 X2_sky130_fd_sc_hd__fill_2
XFILLER_47_492 vssd1 vccd1 vssd1 vccd1 X2_sky130_ef_sc_hd__decap_40_12
XFILLER_34_153 vssd1 vccd1 vssd1 vccd1 X2_sky130_ef_sc_hd__decap_40_12
XFILLER_62_473 vssd1 vccd1 vccd1 vssd1 X2_sky130_fd_sc_hd__fill_2
XFILLER_50_624 vccd1 vssd1 vccd1 vssd1 X2_sky130_fd_sc_hd__fill_1
XFILLER_34_197 vccd1 vssd1 vccd1 vssd1 X2_sky130_fd_sc_hd__fill_1
XTAP_TAPCELL_ROW_9_319 vccd1 vssd1 X2_sky130_fd_sc_hd__tapvpwrvgnd_1
XTAP_TAPCELL_ROW_77_1072 vccd1 vssd1 X2_sky130_fd_sc_hd__tapvpwrvgnd_1
XFILLER_89_337 vssd1 vccd1 vssd1 vccd1 X2_sky130_ef_sc_hd__decap_40_12
XFILLER_57_223 vccd1 vssd1 vccd1 vssd1 X2_sky130_fd_sc_hd__fill_1
XFILLER_17_109 vssd1 vccd1 vccd1 vssd1 X2_sky130_fd_sc_hd__fill_2
XFILLER_57_289 vssd1 vccd1 vccd1 vssd1 X2_sky130_fd_sc_hd__fill_2
XTAP_TAPCELL_ROW_88_1190 vccd1 vssd1 X2_sky130_fd_sc_hd__tapvpwrvgnd_1
XFILLER_82_27 vccd1 vssd1 vccd1 vssd1 X2_sky130_fd_sc_hd__fill_1
XFILLER_41_624 vccd1 vssd1 vccd1 vssd1 X2_sky130_fd_sc_hd__fill_1
XFILLER_13_337 vssd1 vccd1 vssd1 vccd1 X2_sky130_ef_sc_hd__decap_40_12
XFILLER_53_495 vssd1 vccd1 vccd1 vssd1 X2_sky130_fd_sc_hd__fill_8
XFILLER_40_189 vssd1 vccd1 vccd1 vssd1 X2_sky130_fd_sc_hd__fill_2
XFILLER_5_503 vccd1 vssd1 vccd1 vssd1 X2_sky130_fd_sc_hd__fill_1
Xoutput42 vccd1 vssd1 wbs_ack_o _606_/Q vccd1 vssd1 X2_sky130_fd_sc_hd__buf_2
Xoutput53 vccd1 vssd1 wbs_dat_o[4] _561_/Q vccd1 vssd1 X2_sky130_fd_sc_hd__buf_2
XFILLER_95_318 vssd1 vccd1 vssd1 vccd1 X2_sky130_ef_sc_hd__decap_40_12
XFILLER_0_296 vccd1 vssd1 vccd1 vssd1 X2_sky130_fd_sc_hd__fill_1
XFILLER_88_392 vssd1 vccd1 vssd1 vccd1 X2_sky130_ef_sc_hd__decap_40_12
XFILLER_48_212 vssd1 vccd1 vccd1 vssd1 X2_sky130_fd_sc_hd__fill_2
XFILLER_76_587 vccd1 vssd1 vccd1 vssd1 X2_sky130_fd_sc_hd__fill_1
XFILLER_48_245 vssd1 vccd1 vccd1 vssd1 X2_sky130_fd_sc_hd__fill_4
XFILLER_36_429 vssd1 vccd1 vccd1 vssd1 X2_sky130_fd_sc_hd__fill_8
XFILLER_63_237 vssd1 vccd1 vssd1 vccd1 X2_sky130_ef_sc_hd__decap_40_12
XFILLER_56_83 vccd1 vssd1 vccd1 vssd1 X2_sky130_fd_sc_hd__fill_1
XFILLER_91_557 vssd1 vccd1 vccd1 vssd1 X2_sky130_fd_sc_hd__fill_2
XTAP_TAPCELL_ROW_62_906 vccd1 vssd1 X2_sky130_fd_sc_hd__tapvpwrvgnd_1
XFILLER_44_440 vssd1 vccd1 vccd1 vssd1 X2_sky130_fd_sc_hd__fill_2
XFILLER_16_153 vssd1 vccd1 vssd1 vccd1 X2_sky130_ef_sc_hd__decap_40_12
XFILLER_32_624 vccd1 vssd1 vccd1 vssd1 X2_sky130_fd_sc_hd__fill_1
X_577_ vccd1 vssd1 vccd1 vssd1 _577_/Q _497_/Y _577_/D _609_/CLK X2_sky130_fd_sc_hd__dfstp_1
XFILLER_44_462 vccd1 vssd1 vccd1 vssd1 X2_sky130_fd_sc_hd__fill_1
XFILLER_16_197 vssd1 vccd1 vssd1 vccd1 X2_sky130_ef_sc_hd__decap_40_12
XFILLER_71_281 vssd1 vccd1 vssd1 vccd1 X2_sky130_ef_sc_hd__decap_40_12
XFILLER_44_495 vssd1 vccd1 vccd1 vssd1 X2_sky130_fd_sc_hd__fill_2
XFILLER_31_167 vccd1 vssd1 vccd1 vssd1 X2_sky130_fd_sc_hd__fill_1
XTAP_TAPCELL_ROW_14_376 vccd1 vssd1 X2_sky130_fd_sc_hd__tapvpwrvgnd_1
XTAP_TAPCELL_ROW_70_994 vccd1 vssd1 X2_sky130_fd_sc_hd__tapvpwrvgnd_1
XTAP_TAPCELL_ROW_42_685 vccd1 vssd1 X2_sky130_fd_sc_hd__tapvpwrvgnd_1
XFILLER_8_363 vccd1 vssd1 vccd1 vssd1 X2_sky130_fd_sc_hd__fill_1
XFILLER_99_624 vccd1 vssd1 vccd1 vssd1 X2_sky130_fd_sc_hd__fill_1
XFILLER_99_613 vssd1 vccd1 vccd1 vssd1 X2_sky130_fd_sc_hd__fill_2
XFILLER_98_189 vssd1 vccd1 vccd1 vssd1 X2_sky130_fd_sc_hd__fill_4
XFILLER_86_307 vccd1 vssd1 vccd1 vssd1 X2_sky130_fd_sc_hd__fill_1
XFILLER_39_223 vccd1 vssd1 vccd1 vssd1 X2_sky130_fd_sc_hd__fill_1
XFILLER_100_139 vccd1 vssd1 vccd1 vssd1 X2_sky130_fd_sc_hd__fill_1
XFILLER_27_429 vssd1 vccd1 vssd1 vccd1 X2_sky130_ef_sc_hd__decap_40_12
XFILLER_39_278 vssd1 vccd1 vccd1 vssd1 X2_sky130_fd_sc_hd__fill_2
XFILLER_82_513 vssd1 vccd1 vssd1 vccd1 X2_sky130_ef_sc_hd__decap_40_12
XFILLER_82_557 vssd1 vccd1 vssd1 vccd1 X2_sky130_ef_sc_hd__decap_40_12
XFILLER_23_613 vssd1 vccd1 vccd1 vssd1 X2_sky130_fd_sc_hd__fill_2
XFILLER_50_421 vssd1 vccd1 vssd1 vccd1 X2_sky130_ef_sc_hd__decap_40_12
XFILLER_10_307 vccd1 vssd1 vccd1 vssd1 X2_sky130_fd_sc_hd__fill_1
XANTENNA__338__A2 _304_/A vssd1 vccd1 vccd1 vssd1 X2_sky130_fd_sc_hd__diode_2
XFILLER_22_189 vssd1 vccd1 vccd1 vssd1 X2_sky130_fd_sc_hd__fill_4
XFILLER_77_27 vssd1 vccd1 vssd1 vccd1 X2_sky130_ef_sc_hd__decap_40_12
XFILLER_89_167 vccd1 vssd1 vccd1 vssd1 X2_sky130_fd_sc_hd__fill_1
XFILLER_77_329 vssd1 vccd1 vccd1 vssd1 X2_sky130_fd_sc_hd__fill_4
XFILLER_93_15 vssd1 vccd1 vssd1 vccd1 X2_sky130_ef_sc_hd__decap_40_12
X_500_ vccd1 vssd1 vccd1 vssd1 _500_/Y _529_/A X2_sky130_fd_sc_hd__inv_2
XFILLER_85_373 vssd1 vccd1 vssd1 vccd1 X2_sky130_ef_sc_hd__decap_40_12
XFILLER_73_557 vssd1 vccd1 vccd1 vssd1 X2_sky130_fd_sc_hd__fill_2
XFILLER_14_613 vssd1 vccd1 vccd1 vssd1 X2_sky130_fd_sc_hd__fill_8
XFILLER_26_53 vssd1 vccd1 vssd1 vccd1 X2_sky130_ef_sc_hd__decap_40_12
XFILLER_26_473 vssd1 vccd1 vccd1 vssd1 X2_sky130_fd_sc_hd__fill_2
X_431_ vssd1 vccd1 vssd1 vccd1 _431_/X _547_/D hold4/X _549_/D _550_/D X2_sky130_fd_sc_hd__o211a_1
XFILLER_14_624 vccd1 vssd1 vccd1 vssd1 X2_sky130_fd_sc_hd__fill_1
XFILLER_26_97 vssd1 vccd1 vssd1 vccd1 X2_sky130_ef_sc_hd__decap_40_12
XFILLER_53_281 vssd1 vccd1 vssd1 vccd1 X2_sky130_ef_sc_hd__decap_40_12
X_362_ _362_/X _534_/Q _549_/Q vssd1 vccd1 vccd1 vssd1 X2_sky130_fd_sc_hd__and2b_1
XFILLER_9_105 vssd1 vccd1 vccd1 vssd1 X2_sky130_fd_sc_hd__fill_4
XFILLER_13_167 vccd1 vssd1 vccd1 vssd1 X2_sky130_fd_sc_hd__fill_1
XANTENNA__329__A2 _291_/B vssd1 vccd1 vccd1 vssd1 X2_sky130_fd_sc_hd__diode_2
XFILLER_41_476 vssd1 vccd1 vssd1 vccd1 X2_sky130_ef_sc_hd__decap_40_12
XFILLER_9_149 vssd1 vccd1 vssd1 vccd1 X2_sky130_ef_sc_hd__decap_40_12
X_293_ vssd1 vccd1 vccd1 vssd1 _580_/D hold74/X _299_/S _449_/A1 X2_sky130_fd_sc_hd__mux2_1
XFILLER_42_41 vssd1 vccd1 vssd1 vccd1 X2_sky130_ef_sc_hd__decap_40_12
XTAP_TAPCELL_ROW_11_346 vccd1 vssd1 X2_sky130_fd_sc_hd__tapvpwrvgnd_1
XFILLER_42_85 vssd1 vccd1 vssd1 vccd1 X2_sky130_ef_sc_hd__decap_40_12
XFILLER_5_333 vssd1 vccd1 vccd1 vssd1 X2_sky130_fd_sc_hd__fill_2
XTAP_TAPCELL_ROW_97_1289 vccd1 vssd1 X2_sky130_fd_sc_hd__tapvpwrvgnd_1
XFILLER_1_561 vssd1 vccd1 vssd1 vccd1 X2_sky130_ef_sc_hd__decap_40_12
XFILLER_68_307 vccd1 vssd1 vccd1 vssd1 X2_sky130_fd_sc_hd__fill_1
XFILLER_3_57 vssd1 vccd1 vssd1 vccd1 X2_sky130_ef_sc_hd__decap_40_12
XFILLER_95_137 vssd1 vccd1 vssd1 vccd1 X2_sky130_ef_sc_hd__decap_40_12
XFILLER_49_532 vssd1 vccd1 vssd1 vccd1 X2_sky130_ef_sc_hd__decap_40_12
XFILLER_67_93 vssd1 vccd1 vssd1 vccd1 X2_sky130_ef_sc_hd__decap_40_12
XFILLER_64_502 vssd1 vccd1 vssd1 vccd1 X2_sky130_ef_sc_hd__decap_40_12
XTAP_TAPCELL_ROW_19_424 vccd1 vssd1 X2_sky130_fd_sc_hd__tapvpwrvgnd_1
XFILLER_36_237 vssd1 vccd1 vccd1 vssd1 X2_sky130_fd_sc_hd__fill_8
XFILLER_36_259 vssd1 vccd1 vssd1 vccd1 X2_sky130_ef_sc_hd__decap_40_12
XFILLER_64_557 vssd1 vccd1 vccd1 vssd1 X2_sky130_fd_sc_hd__fill_4
XTAP_TAPCELL_ROW_47_733 vccd1 vssd1 X2_sky130_fd_sc_hd__tapvpwrvgnd_1
XFILLER_17_473 vssd1 vccd1 vssd1 vccd1 X2_sky130_ef_sc_hd__decap_40_12
XFILLER_91_376 vssd1 vccd1 vssd1 vccd1 X2_sky130_ef_sc_hd__decap_40_12
XFILLER_32_421 vssd1 vccd1 vssd1 vccd1 X2_sky130_ef_sc_hd__decap_40_12
XFILLER_83_81 vssd1 vccd1 vssd1 vccd1 X2_sky130_ef_sc_hd__decap_40_12
XFILLER_80_3 vssd1 vccd1 vssd1 vccd1 X2_sky130_ef_sc_hd__decap_40_12
XFILLER_8_193 vssd1 vccd1 vccd1 vssd1 X2_sky130_fd_sc_hd__fill_2
XFILLER_99_410 vssd1 vccd1 vccd1 vssd1 X2_sky130_fd_sc_hd__fill_2
XANTENNA__304__B _317_/B vssd1 vccd1 vccd1 vssd1 X2_sky130_fd_sc_hd__diode_2
XTAP_TAPCELL_ROW_74_1031 vccd1 vssd1 X2_sky130_fd_sc_hd__tapvpwrvgnd_1
XFILLER_86_137 vssd1 vccd1 vccd1 vssd1 X2_sky130_fd_sc_hd__fill_2
XFILLER_67_373 vssd1 vccd1 vssd1 vccd1 X2_sky130_ef_sc_hd__decap_40_12
XFILLER_27_237 vssd1 vccd1 vssd1 vccd1 X2_sky130_ef_sc_hd__decap_40_12
XFILLER_82_321 vssd1 vccd1 vssd1 vccd1 X2_sky130_ef_sc_hd__decap_40_12
XFILLER_55_557 vssd1 vccd1 vccd1 vssd1 X2_sky130_fd_sc_hd__fill_2
XFILLER_82_365 vssd1 vccd1 vssd1 vccd1 X2_sky130_ef_sc_hd__decap_40_12
XFILLER_35_281 vssd1 vccd1 vssd1 vccd1 X2_sky130_ef_sc_hd__decap_40_12
XTAP_TAPCELL_ROW_85_1160 vccd1 vssd1 X2_sky130_fd_sc_hd__tapvpwrvgnd_1
XFILLER_42_229 vccd1 vssd1 vccd1 vssd1 X2_sky130_fd_sc_hd__fill_1
XFILLER_50_251 vccd1 vssd1 vccd1 vssd1 X2_sky130_fd_sc_hd__fill_1
XFILLER_7_609 vssd1 vccd1 vccd1 vssd1 X2_sky130_fd_sc_hd__fill_4
XFILLER_10_137 vssd1 vccd1 vccd1 vssd1 X2_sky130_fd_sc_hd__fill_2
XFILLER_12_77 vssd1 vccd1 vccd1 vssd1 X2_sky130_fd_sc_hd__fill_4
XFILLER_88_15 vssd1 vccd1 vssd1 vccd1 X2_sky130_ef_sc_hd__decap_40_12
XFILLER_77_137 vssd1 vccd1 vssd1 vccd1 X2_sky130_ef_sc_hd__decap_40_12
XFILLER_46_513 vssd1 vccd1 vccd1 vssd1 X2_sky130_fd_sc_hd__fill_2
XFILLER_85_181 vssd1 vccd1 vssd1 vccd1 X2_sky130_ef_sc_hd__decap_40_12
XFILLER_61_505 vssd1 vccd1 vssd1 vccd1 X2_sky130_ef_sc_hd__decap_40_12
XTAP_TAPCELL_ROW_44_703 vccd1 vssd1 X2_sky130_fd_sc_hd__tapvpwrvgnd_1
XFILLER_14_421 vssd1 vccd1 vssd1 vccd1 X2_sky130_ef_sc_hd__decap_40_12
X_414_ vssd1 vccd1 _414_/B _414_/Y _414_/A vccd1 vssd1 X2_sky130_fd_sc_hd__xnor2_1
XFILLER_53_51 vssd1 vccd1 vccd1 vssd1 X2_sky130_fd_sc_hd__fill_4
X_345_ vccd1 vssd1 vccd1 vssd1 _586_/Q _588_/Q _589_/Q _587_/Q _347_/A X2_sky130_fd_sc_hd__or4_1
XTAP_TAPCELL_ROW_99_1307 vccd1 vssd1 X2_sky130_fd_sc_hd__tapvpwrvgnd_1
XTAP_TAPCELL_ROW_24_482 vccd1 vssd1 X2_sky130_fd_sc_hd__tapvpwrvgnd_1
X_276_ vssd1 vccd1 vccd1 vssd1 _603_/D hold7/X _289_/S _276_/A0 X2_sky130_fd_sc_hd__mux2_1
XTAP_TAPCELL_ROW_52_791 vccd1 vssd1 X2_sky130_fd_sc_hd__tapvpwrvgnd_1
XFILLER_78_81 vssd1 vccd1 vccd1 vssd1 X2_sky130_fd_sc_hd__fill_2
XFILLER_68_137 vssd1 vccd1 vccd1 vssd1 X2_sky130_fd_sc_hd__fill_2
XFILLER_96_457 vssd1 vccd1 vssd1 vccd1 X2_sky130_ef_sc_hd__decap_40_12
XFILLER_37_557 vssd1 vccd1 vccd1 vssd1 X2_sky130_fd_sc_hd__fill_2
XANTENNA__286__S _289_/S vssd1 vccd1 vccd1 vssd1 X2_sky130_fd_sc_hd__diode_2
XFILLER_64_365 vssd1 vccd1 vssd1 vccd1 X2_sky130_ef_sc_hd__decap_40_12
XFILLER_17_281 vssd1 vccd1 vssd1 vccd1 X2_sky130_ef_sc_hd__decap_40_12
XFILLER_20_413 vssd1 vccd1 vccd1 vssd1 X2_sky130_fd_sc_hd__fill_4
XFILLER_32_251 vccd1 vssd1 vccd1 vssd1 X2_sky130_fd_sc_hd__fill_1
XFILLER_20_457 vssd1 vccd1 vssd1 vccd1 X2_sky130_ef_sc_hd__decap_40_12
XANTENNA__600__CLK _601_/CLK vssd1 vccd1 vccd1 vssd1 X2_sky130_fd_sc_hd__diode_2
XPHY_EDGE_ROW_12_Right_12 vccd1 vssd1 vccd1 vssd1 X2_sky130_fd_sc_hd__decap_3
XFILLER_58_29 vssd1 vccd1 vssd1 vccd1 X2_sky130_ef_sc_hd__decap_40_12
XFILLER_99_273 vssd1 vccd1 vccd1 vssd1 X2_sky130_fd_sc_hd__fill_4
XFILLER_59_137 vssd1 vccd1 vssd1 vccd1 X2_sky130_ef_sc_hd__decap_40_12
XFILLER_28_513 vssd1 vccd1 vssd1 vccd1 X2_sky130_ef_sc_hd__decap_40_12
XFILLER_28_557 vssd1 vccd1 vssd1 vccd1 X2_sky130_ef_sc_hd__decap_40_12
XFILLER_67_181 vssd1 vccd1 vssd1 vccd1 X2_sky130_ef_sc_hd__decap_40_12
XFILLER_55_332 vssd1 vccd1 vccd1 vssd1 X2_sky130_fd_sc_hd__fill_4
XPHY_EDGE_ROW_21_Right_21 vccd1 vssd1 vccd1 vssd1 X2_sky130_fd_sc_hd__decap_3
XFILLER_43_505 vssd1 vccd1 vccd1 vssd1 X2_sky130_fd_sc_hd__fill_2
XFILLER_82_195 vccd1 vssd1 vccd1 vssd1 X2_sky130_fd_sc_hd__fill_1
XFILLER_43_527 vssd1 vccd1 vssd1 vccd1 X2_sky130_ef_sc_hd__decap_40_12
XFILLER_90_27 vccd1 vssd1 vccd1 vssd1 X2_sky130_fd_sc_hd__fill_1
XFILLER_70_357 vssd1 vccd1 vccd1 vssd1 X2_sky130_fd_sc_hd__fill_4
XFILLER_23_273 vssd1 vccd1 vccd1 vssd1 X2_sky130_fd_sc_hd__fill_4
XFILLER_51_571 vccd1 vssd1 vccd1 vssd1 X2_sky130_fd_sc_hd__fill_1
XFILLER_7_417 vssd1 vccd1 vssd1 vccd1 X2_sky130_ef_sc_hd__decap_40_12
XTAP_TAPCELL_ROW_21_452 vccd1 vssd1 X2_sky130_fd_sc_hd__tapvpwrvgnd_1
XPHY_EDGE_ROW_30_Right_30 vccd1 vssd1 vccd1 vssd1 X2_sky130_fd_sc_hd__decap_3
XFILLER_99_69 vssd1 vccd1 vssd1 vccd1 X2_sky130_ef_sc_hd__decap_40_12
XTAP_TAPCELL_ROW_94_1259 vccd1 vssd1 X2_sky130_fd_sc_hd__tapvpwrvgnd_1
XFILLER_2_133 vssd1 vccd1 vccd1 vssd1 X2_sky130_fd_sc_hd__fill_4
XFILLER_2_177 vssd1 vccd1 vssd1 vccd1 X2_sky130_ef_sc_hd__decap_40_12
XFILLER_78_413 vssd1 vccd1 vccd1 vssd1 X2_sky130_fd_sc_hd__fill_4
XFILLER_93_405 vssd1 vccd1 vssd1 vccd1 X2_sky130_ef_sc_hd__decap_40_12
XFILLER_78_457 vssd1 vccd1 vssd1 vccd1 X2_sky130_ef_sc_hd__decap_40_12
XANTENNA_clkbuf_3_5__f_wb_clk_i_A clkbuf_0_wb_clk_i/X vssd1 vccd1 vccd1 vssd1 X2_sky130_fd_sc_hd__diode_2
XFILLER_19_557 vssd1 vccd1 vccd1 vssd1 X2_sky130_fd_sc_hd__fill_2
XFILLER_93_449 vssd1 vccd1 vssd1 vccd1 X2_sky130_ef_sc_hd__decap_40_12
XFILLER_0_69 vssd1 vccd1 vssd1 vccd1 X2_sky130_ef_sc_hd__decap_40_12
XTAP_TAPCELL_ROW_29_541 vccd1 vssd1 X2_sky130_fd_sc_hd__tapvpwrvgnd_1
XTAP_TAPCELL_ROW_57_850 vccd1 vssd1 X2_sky130_fd_sc_hd__tapvpwrvgnd_1
XFILLER_46_365 vccd1 vssd1 vccd1 vssd1 X2_sky130_fd_sc_hd__fill_1
XFILLER_46_354 vssd1 vccd1 vccd1 vssd1 X2_sky130_fd_sc_hd__fill_8
XFILLER_64_83 vccd1 vssd1 vccd1 vssd1 X2_sky130_fd_sc_hd__fill_1
XFILLER_14_251 vccd1 vssd1 vccd1 vssd1 X2_sky130_fd_sc_hd__fill_1
X_328_ vccd1 vssd1 vssd1 vccd1 _327_/X _317_/B hold17/X _326_/X _328_/X X2_sky130_fd_sc_hd__o22a_1
XTAP_TAPCELL_ROW_71_1001 vccd1 vssd1 X2_sky130_fd_sc_hd__tapvpwrvgnd_1
XFILLER_43_3 vssd1 vccd1 vssd1 vccd1 X2_sky130_ef_sc_hd__decap_40_12
XFILLER_96_221 vssd1 vccd1 vssd1 vccd1 X2_sky130_ef_sc_hd__decap_40_12
XFILLER_96_265 vssd1 vccd1 vssd1 vccd1 X2_sky130_ef_sc_hd__decap_40_12
XFILLER_49_181 vssd1 vccd1 vssd1 vccd1 X2_sky130_ef_sc_hd__decap_40_12
XFILLER_25_505 vssd1 vccd1 vssd1 vccd1 X2_sky130_ef_sc_hd__decap_40_12
XFILLER_37_354 vssd1 vccd1 vccd1 vssd1 X2_sky130_fd_sc_hd__fill_2
XFILLER_37_387 vssd1 vccd1 vccd1 vssd1 X2_sky130_fd_sc_hd__fill_4
XFILLER_64_195 vccd1 vssd1 vccd1 vssd1 X2_sky130_fd_sc_hd__fill_1
XFILLER_52_335 vssd1 vccd1 vccd1 vssd1 X2_sky130_fd_sc_hd__fill_2
XFILLER_100_15 vssd1 vccd1 vssd1 vccd1 X2_sky130_ef_sc_hd__decap_40_12
XFILLER_20_221 vssd1 vccd1 vssd1 vccd1 X2_sky130_ef_sc_hd__decap_40_12
XFILLER_20_265 vssd1 vccd1 vssd1 vccd1 X2_sky130_ef_sc_hd__decap_40_12
XFILLER_69_39 vssd1 vccd1 vssd1 vccd1 X2_sky130_ef_sc_hd__decap_40_12
XFILLER_0_615 vccd1 vssd1 vccd1 vssd1 X2_sky130_fd_sc_hd__fill_1
XFILLER_87_221 vssd1 vccd1 vccd1 vssd1 X2_sky130_fd_sc_hd__fill_2
XFILLER_85_27 vssd1 vccd1 vssd1 vccd1 X2_sky130_ef_sc_hd__decap_40_12
XFILLER_75_405 vssd1 vccd1 vssd1 vccd1 X2_sky130_ef_sc_hd__decap_40_12
XFILLER_48_619 vssd1 vccd1 vccd1 vssd1 X2_sky130_fd_sc_hd__fill_2
XFILLER_28_321 vssd1 vccd1 vssd1 vccd1 X2_sky130_ef_sc_hd__decap_40_12
XFILLER_75_449 vssd1 vccd1 vssd1 vccd1 X2_sky130_ef_sc_hd__decap_40_12
XFILLER_18_65 vssd1 vccd1 vssd1 vccd1 X2_sky130_ef_sc_hd__decap_40_12
XFILLER_28_365 vssd1 vccd1 vssd1 vccd1 X2_sky130_ef_sc_hd__decap_40_12
XFILLER_90_419 vccd1 vssd1 vccd1 vssd1 X2_sky130_fd_sc_hd__fill_1
Xclkbuf_3_6__f_wb_clk_i vssd1 vccd1 vssd1 vccd1 clkbuf_0_wb_clk_i/X _607_/CLK X2_sky130_fd_sc_hd__clkbuf_16
XTAP_TAPCELL_ROW_26_511 vccd1 vssd1 X2_sky130_fd_sc_hd__tapvpwrvgnd_1
XFILLER_43_335 vccd1 vssd1 vccd1 vssd1 X2_sky130_fd_sc_hd__fill_1
XFILLER_70_121 vssd1 vccd1 vssd1 vccd1 X2_sky130_ef_sc_hd__decap_40_12
XFILLER_43_368 vssd1 vccd1 vccd1 vssd1 X2_sky130_fd_sc_hd__fill_8
XFILLER_34_53 vssd1 vccd1 vssd1 vccd1 X2_sky130_ef_sc_hd__decap_40_12
XFILLER_70_165 vssd1 vccd1 vssd1 vccd1 X2_sky130_ef_sc_hd__decap_40_12
XFILLER_11_221 vssd1 vccd1 vccd1 vssd1 X2_sky130_fd_sc_hd__fill_2
XFILLER_34_97 vssd1 vccd1 vssd1 vccd1 X2_sky130_ef_sc_hd__decap_40_12
XFILLER_7_225 vssd1 vccd1 vssd1 vccd1 X2_sky130_ef_sc_hd__decap_40_12
XFILLER_50_41 vssd1 vccd1 vssd1 vccd1 X2_sky130_ef_sc_hd__decap_40_12
XFILLER_50_85 vssd1 vccd1 vssd1 vccd1 X2_sky130_ef_sc_hd__decap_40_12
XFILLER_3_497 vssd1 vccd1 vccd1 vssd1 X2_sky130_fd_sc_hd__fill_4
XFILLER_78_221 vssd1 vccd1 vssd1 vccd1 X2_sky130_ef_sc_hd__decap_40_12
XFILLER_39_619 vccd1 vssd1 vccd1 vssd1 X2_sky130_fd_sc_hd__fill_1
XFILLER_78_265 vssd1 vccd1 vssd1 vccd1 X2_sky130_ef_sc_hd__decap_40_12
XTAP_TAPCELL_ROW_6_291 vccd1 vssd1 X2_sky130_fd_sc_hd__tapvpwrvgnd_1
XFILLER_75_93 vssd1 vccd1 vssd1 vccd1 X2_sky130_ef_sc_hd__decap_40_12
XFILLER_46_195 vccd1 vssd1 vccd1 vssd1 X2_sky130_fd_sc_hd__fill_1
XFILLER_61_165 vssd1 vccd1 vccd1 vssd1 X2_sky130_fd_sc_hd__fill_2
XFILLER_91_81 vssd1 vccd1 vssd1 vccd1 X2_sky130_ef_sc_hd__decap_40_12
XTAP_TAPCELL_ROW_32_569 vccd1 vssd1 X2_sky130_fd_sc_hd__tapvpwrvgnd_1
XTAP_TAPCELL_ROW_60_878 vccd1 vssd1 X2_sky130_fd_sc_hd__tapvpwrvgnd_1
XFILLER_30_585 vssd1 vccd1 vccd1 vssd1 X2_sky130_fd_sc_hd__fill_2
XFILLER_97_541 vssd1 vccd1 vssd1 vccd1 X2_sky130_ef_sc_hd__decap_40_12
XFILLER_69_221 vssd1 vccd1 vccd1 vssd1 X2_sky130_fd_sc_hd__fill_2
XFILLER_97_585 vssd1 vccd1 vssd1 vccd1 X2_sky130_ef_sc_hd__decap_40_12
XFILLER_57_405 vssd1 vccd1 vssd1 vccd1 X2_sky130_ef_sc_hd__decap_40_12
XFILLER_57_449 vssd1 vccd1 vssd1 vccd1 X2_sky130_ef_sc_hd__decap_40_12
XFILLER_72_419 vccd1 vssd1 vccd1 vssd1 X2_sky130_fd_sc_hd__fill_1
XTAP_TAPCELL_ROW_68_967 vccd1 vssd1 X2_sky130_fd_sc_hd__tapvpwrvgnd_1
XPHY_EDGE_ROW_9_Left_111 vccd1 vssd1 vccd1 vssd1 X2_sky130_fd_sc_hd__decap_3
XFILLER_25_335 vccd1 vssd1 vccd1 vssd1 X2_sky130_fd_sc_hd__fill_1
XFILLER_52_121 vssd1 vccd1 vssd1 vccd1 X2_sky130_ef_sc_hd__decap_40_12
XFILLER_52_165 vssd1 vccd1 vssd1 vccd1 X2_sky130_ef_sc_hd__decap_40_12
XFILLER_21_541 vssd1 vccd1 vssd1 vccd1 X2_sky130_ef_sc_hd__decap_40_12
XFILLER_21_585 vssd1 vccd1 vssd1 vccd1 X2_sky130_ef_sc_hd__decap_40_12
XANTENNA__503__A _527_/A vssd1 vccd1 vccd1 vssd1 X2_sky130_fd_sc_hd__diode_2
XFILLER_20_77 vssd1 vccd1 vccd1 vssd1 X2_sky130_fd_sc_hd__fill_4
XTAP_TAPCELL_ROW_91_1218 vccd1 vssd1 X2_sky130_fd_sc_hd__tapvpwrvgnd_1
XFILLER_96_15 vssd1 vccd1 vssd1 vccd1 X2_sky130_ef_sc_hd__decap_40_12
XFILLER_0_445 vssd1 vccd1 vccd1 vssd1 X2_sky130_fd_sc_hd__fill_2
XFILLER_0_489 vssd1 vccd1 vssd1 vccd1 X2_sky130_ef_sc_hd__decap_40_12
XFILLER_88_585 vssd1 vccd1 vccd1 vssd1 X2_sky130_fd_sc_hd__fill_2
Xhold31 _566_/D _316_/X vccd1 vssd1 vssd1 vccd1 X2_sky130_fd_sc_hd__dlygate4sd3_1
Xhold20 _553_/D _538_/Q vccd1 vssd1 vssd1 vccd1 X2_sky130_fd_sc_hd__dlygate4sd3_1
XFILLER_48_416 vssd1 vccd1 vccd1 vssd1 X2_sky130_fd_sc_hd__fill_4
Xhold42 hold42/X _595_/Q vccd1 vssd1 vssd1 vccd1 X2_sky130_fd_sc_hd__dlygate4sd3_1
Xhold53 hold53/X _584_/Q vccd1 vssd1 vssd1 vccd1 X2_sky130_fd_sc_hd__dlygate4sd3_1
Xhold64 hold64/X _558_/Q vccd1 vssd1 vssd1 vccd1 X2_sky130_fd_sc_hd__dlygate4sd3_1
XTAP_TAPCELL_ROW_3_250 vccd1 vssd1 X2_sky130_fd_sc_hd__tapvpwrvgnd_1
Xhold75 hold75/X _594_/Q vccd1 vssd1 vssd1 vccd1 X2_sky130_fd_sc_hd__dlygate4sd3_1
XFILLER_75_279 vccd1 vssd1 vccd1 vssd1 X2_sky130_fd_sc_hd__fill_1
Xhold86 _543_/D _438_/Y vccd1 vssd1 vssd1 vccd1 X2_sky130_fd_sc_hd__dlygate4sd3_1
XFILLER_44_622 vssd1 vccd1 vccd1 vssd1 X2_sky130_fd_sc_hd__fill_2
XFILLER_44_600 vssd1 vccd1 vccd1 vssd1 X2_sky130_fd_sc_hd__fill_2
XFILLER_16_357 vssd1 vccd1 vccd1 vssd1 X2_sky130_fd_sc_hd__fill_4
XFILLER_28_195 vccd1 vssd1 vccd1 vssd1 X2_sky130_fd_sc_hd__fill_1
X_593_ vssd1 vccd1 vccd1 vssd1 _609_/CLK _593_/D _513_/Y _593_/Q X2_sky130_fd_sc_hd__dfrtp_1
XFILLER_90_249 vssd1 vccd1 vccd1 vssd1 X2_sky130_fd_sc_hd__fill_2
XFILLER_71_441 vssd1 vccd1 vccd1 vssd1 X2_sky130_fd_sc_hd__fill_4
XFILLER_31_305 vssd1 vccd1 vccd1 vssd1 X2_sky130_fd_sc_hd__fill_2
XFILLER_71_485 vssd1 vccd1 vssd1 vccd1 X2_sky130_ef_sc_hd__decap_40_12
XFILLER_43_165 vssd1 vccd1 vccd1 vssd1 X2_sky130_fd_sc_hd__fill_2
XTAP_TAPCELL_ROW_100_1325 vccd1 vssd1 X2_sky130_fd_sc_hd__tapvpwrvgnd_1
XFILLER_8_501 vssd1 vccd1 vssd1 vccd1 X2_sky130_ef_sc_hd__decap_40_12
XFILLER_61_51 vssd1 vccd1 vccd1 vssd1 X2_sky130_fd_sc_hd__fill_4
XFILLER_8_545 vssd1 vccd1 vssd1 vccd1 X2_sky130_ef_sc_hd__decap_40_12
XFILLER_12_585 vssd1 vccd1 vccd1 vssd1 X2_sky130_fd_sc_hd__fill_2
XFILLER_8_589 vssd1 vccd1 vssd1 vccd1 X2_sky130_ef_sc_hd__decap_40_12
XFILLER_98_305 vssd1 vccd1 vccd1 vssd1 X2_sky130_fd_sc_hd__fill_2
XFILLER_3_261 vssd1 vccd1 vssd1 vccd1 X2_sky130_ef_sc_hd__decap_40_12
XFILLER_79_541 vssd1 vccd1 vssd1 vccd1 X2_sky130_ef_sc_hd__decap_40_12
XFILLER_39_405 vssd1 vccd1 vssd1 vccd1 X2_sky130_ef_sc_hd__decap_40_12
XFILLER_79_585 vssd1 vccd1 vssd1 vccd1 X2_sky130_ef_sc_hd__decap_40_12
XFILLER_39_449 vssd1 vccd1 vssd1 vccd1 X2_sky130_ef_sc_hd__decap_40_12
XFILLER_94_533 vssd1 vccd1 vssd1 vccd1 X2_sky130_ef_sc_hd__decap_40_12
XFILLER_86_81 vssd1 vccd1 vccd1 vssd1 X2_sky130_fd_sc_hd__fill_2
XFILLER_54_419 vccd1 vssd1 vccd1 vssd1 X2_sky130_fd_sc_hd__fill_1
XTAP_TAPCELL_ROW_37_628 vccd1 vssd1 X2_sky130_fd_sc_hd__tapvpwrvgnd_1
XFILLER_81_205 vssd1 vccd1 vssd1 vccd1 X2_sky130_ef_sc_hd__decap_40_12
XTAP_TAPCELL_ROW_65_937 vccd1 vssd1 X2_sky130_fd_sc_hd__tapvpwrvgnd_1
XFILLER_34_121 vssd1 vccd1 vssd1 vccd1 X2_sky130_ef_sc_hd__decap_40_12
XFILLER_81_249 vssd1 vccd1 vssd1 vccd1 X2_sky130_ef_sc_hd__decap_40_12
XFILLER_22_305 vssd1 vccd1 vccd1 vssd1 X2_sky130_fd_sc_hd__fill_2
XFILLER_34_165 vssd1 vccd1 vssd1 vccd1 X2_sky130_ef_sc_hd__decap_40_12
XANTENNA__294__S _299_/S vssd1 vccd1 vccd1 vssd1 X2_sky130_fd_sc_hd__diode_2
XPHY_EDGE_ROW_6_Right_6 vccd1 vssd1 vccd1 vssd1 X2_sky130_fd_sc_hd__decap_3
XTAP_TAPCELL_ROW_77_1062 vccd1 vssd1 X2_sky130_fd_sc_hd__tapvpwrvgnd_1
XFILLER_89_305 vssd1 vccd1 vccd1 vssd1 X2_sky130_fd_sc_hd__fill_2
XFILLER_89_349 vssd1 vccd1 vssd1 vccd1 X2_sky130_ef_sc_hd__decap_40_12
XFILLER_66_18 vssd1 vccd1 vccd1 vssd1 X2_sky130_fd_sc_hd__fill_8
XFILLER_97_393 vssd1 vccd1 vssd1 vccd1 X2_sky130_ef_sc_hd__decap_40_12
XFILLER_66_29 vssd1 vccd1 vssd1 vccd1 X2_sky130_ef_sc_hd__decap_40_12
XTAP_TAPCELL_ROW_0_220 vccd1 vssd1 X2_sky130_fd_sc_hd__tapvpwrvgnd_1
XFILLER_57_279 vccd1 vssd1 vccd1 vssd1 X2_sky130_fd_sc_hd__fill_1
XTAP_TAPCELL_ROW_88_1191 vccd1 vssd1 X2_sky130_fd_sc_hd__tapvpwrvgnd_1
XFILLER_72_249 vssd1 vccd1 vccd1 vssd1 X2_sky130_fd_sc_hd__fill_2
XFILLER_65_290 vssd1 vccd1 vccd1 vssd1 X2_sky130_fd_sc_hd__fill_2
XFILLER_13_305 vssd1 vccd1 vssd1 vccd1 X2_sky130_ef_sc_hd__decap_40_12
XFILLER_25_165 vssd1 vccd1 vccd1 vssd1 X2_sky130_fd_sc_hd__fill_2
XFILLER_53_474 vccd1 vssd1 vccd1 vssd1 X2_sky130_fd_sc_hd__fill_1
XFILLER_13_349 vssd1 vccd1 vssd1 vccd1 X2_sky130_ef_sc_hd__decap_40_12
XFILLER_15_55 vccd1 vssd1 vccd1 vssd1 X2_sky130_fd_sc_hd__fill_1
XFILLER_21_393 vssd1 vccd1 vssd1 vccd1 X2_sky130_ef_sc_hd__decap_40_12
XFILLER_5_559 vccd1 vssd1 vccd1 vssd1 X2_sky130_fd_sc_hd__fill_1
Xoutput43 vccd1 vssd1 wbs_dat_o[0] _557_/Q vccd1 vssd1 X2_sky130_fd_sc_hd__buf_2
Xoutput54 vccd1 vssd1 wbs_dat_o[5] _562_/Q vccd1 vssd1 X2_sky130_fd_sc_hd__buf_2
XFILLER_0_253 vssd1 vccd1 vccd1 vssd1 X2_sky130_fd_sc_hd__fill_2
XFILLER_88_360 vssd1 vccd1 vccd1 vssd1 X2_sky130_fd_sc_hd__fill_4
XFILLER_95_308 vssd1 vccd1 vccd1 vssd1 X2_sky130_fd_sc_hd__fill_2
XFILLER_0_286 vssd1 vccd1 vccd1 vssd1 X2_sky130_fd_sc_hd__fill_2
XANTENNA_input30_A wbs_dat_i[1] vssd1 vccd1 vccd1 vssd1 X2_sky130_fd_sc_hd__diode_2
XFILLER_76_533 vssd1 vccd1 vssd1 vccd1 X2_sky130_ef_sc_hd__decap_40_12
XFILLER_91_503 vccd1 vssd1 vccd1 vssd1 X2_sky130_fd_sc_hd__fill_1
XFILLER_36_419 vccd1 vssd1 vccd1 vssd1 X2_sky130_fd_sc_hd__fill_1
XFILLER_16_121 vssd1 vccd1 vssd1 vccd1 X2_sky130_ef_sc_hd__decap_40_12
XFILLER_63_249 vssd1 vccd1 vssd1 vccd1 X2_sky130_ef_sc_hd__decap_40_12
XTAP_TAPCELL_ROW_62_907 vccd1 vssd1 X2_sky130_fd_sc_hd__tapvpwrvgnd_1
XFILLER_44_430 vssd1 vccd1 vccd1 vssd1 X2_sky130_fd_sc_hd__fill_2
XFILLER_16_165 vssd1 vccd1 vssd1 vccd1 X2_sky130_ef_sc_hd__decap_40_12
X_576_ vccd1 vssd1 vccd1 vssd1 _576_/Q _496_/Y _576_/D _609_/CLK X2_sky130_fd_sc_hd__dfstp_1
XFILLER_31_113 vssd1 vccd1 vssd1 vccd1 X2_sky130_ef_sc_hd__decap_40_12
XFILLER_71_293 vssd1 vccd1 vssd1 vccd1 X2_sky130_ef_sc_hd__decap_40_12
XFILLER_72_83 vccd1 vssd1 vccd1 vssd1 X2_sky130_fd_sc_hd__fill_1
XTAP_TAPCELL_ROW_14_377 vccd1 vssd1 X2_sky130_fd_sc_hd__tapvpwrvgnd_1
XTAP_TAPCELL_ROW_70_995 vccd1 vssd1 X2_sky130_fd_sc_hd__tapvpwrvgnd_1
XPHY_EDGE_ROW_59_Right_59 vccd1 vssd1 vccd1 vssd1 X2_sky130_fd_sc_hd__decap_3
XTAP_TAPCELL_ROW_42_686 vccd1 vssd1 X2_sky130_fd_sc_hd__tapvpwrvgnd_1
XFILLER_4_581 vssd1 vccd1 vccd1 vssd1 X2_sky130_fd_sc_hd__fill_4
XFILLER_79_393 vssd1 vccd1 vssd1 vccd1 X2_sky130_ef_sc_hd__decap_40_12
XPHY_EDGE_ROW_68_Right_68 vccd1 vssd1 vccd1 vssd1 X2_sky130_fd_sc_hd__decap_3
XANTENNA__289__S _289_/S vssd1 vccd1 vccd1 vssd1 X2_sky130_fd_sc_hd__diode_2
XFILLER_94_363 vccd1 vssd1 vccd1 vssd1 X2_sky130_fd_sc_hd__fill_1
XFILLER_82_525 vssd1 vccd1 vccd1 vssd1 X2_sky130_fd_sc_hd__fill_4
XFILLER_54_205 vccd1 vssd1 vccd1 vssd1 X2_sky130_fd_sc_hd__fill_1
XFILLER_82_569 vssd1 vccd1 vssd1 vccd1 X2_sky130_ef_sc_hd__decap_40_12
XFILLER_47_290 vssd1 vccd1 vssd1 vccd1 X2_sky130_ef_sc_hd__decap_40_12
XFILLER_50_433 vssd1 vccd1 vccd1 vssd1 X2_sky130_fd_sc_hd__fill_4
XPHY_EDGE_ROW_99_Left_201 vccd1 vssd1 vccd1 vssd1 X2_sky130_fd_sc_hd__decap_3
XPHY_EDGE_ROW_77_Right_77 vccd1 vssd1 vccd1 vssd1 X2_sky130_fd_sc_hd__decap_3
XFILLER_50_477 vssd1 vccd1 vccd1 vssd1 X2_sky130_fd_sc_hd__fill_8
XFILLER_2_529 vssd1 vccd1 vccd1 vssd1 X2_sky130_fd_sc_hd__fill_2
XFILLER_89_113 vssd1 vccd1 vssd1 vccd1 X2_sky130_ef_sc_hd__decap_40_12
XPHY_EDGE_ROW_86_Right_86 vccd1 vssd1 vccd1 vssd1 X2_sky130_fd_sc_hd__decap_3
XFILLER_77_39 vssd1 vccd1 vssd1 vccd1 X2_sky130_ef_sc_hd__decap_40_12
XFILLER_58_533 vssd1 vccd1 vssd1 vccd1 X2_sky130_ef_sc_hd__decap_40_12
XFILLER_18_419 vccd1 vssd1 vccd1 vssd1 X2_sky130_fd_sc_hd__fill_1
XFILLER_93_27 vssd1 vccd1 vssd1 vccd1 X2_sky130_ef_sc_hd__decap_40_12
XFILLER_85_385 vssd1 vccd1 vccd1 vssd1 X2_sky130_fd_sc_hd__fill_4
XFILLER_73_503 vccd1 vssd1 vccd1 vssd1 X2_sky130_fd_sc_hd__fill_1
XFILLER_45_249 vssd1 vccd1 vssd1 vccd1 X2_sky130_ef_sc_hd__decap_40_12
XFILLER_26_65 vssd1 vccd1 vssd1 vccd1 X2_sky130_ef_sc_hd__decap_40_12
X_430_ vssd1 vccd1 _434_/A _556_/D _555_/D _430_/C vccd1 vssd1 X2_sky130_fd_sc_hd__and3_1
XFILLER_13_113 vssd1 vccd1 vssd1 vccd1 X2_sky130_ef_sc_hd__decap_40_12
XPHY_EDGE_ROW_95_Right_95 vccd1 vssd1 vccd1 vssd1 X2_sky130_fd_sc_hd__decap_3
XFILLER_53_293 vssd1 vccd1 vssd1 vccd1 X2_sky130_ef_sc_hd__decap_40_12
X_361_ vssd1 vccd1 _411_/A _535_/Q _550_/Q vccd1 vssd1 X2_sky130_fd_sc_hd__xnor2_2
X_292_ vssd1 vccd1 vccd1 vssd1 _581_/D hold71/X _299_/S _450_/A1 X2_sky130_fd_sc_hd__mux2_1
XFILLER_42_53 vssd1 vccd1 vssd1 vccd1 X2_sky130_ef_sc_hd__decap_40_12
XFILLER_41_488 vssd1 vccd1 vssd1 vccd1 X2_sky130_ef_sc_hd__decap_40_12
XTAP_TAPCELL_ROW_11_336 vccd1 vssd1 X2_sky130_fd_sc_hd__tapvpwrvgnd_1
XFILLER_42_97 vssd1 vccd1 vssd1 vccd1 X2_sky130_ef_sc_hd__decap_40_12
XFILLER_5_389 vssd1 vccd1 vccd1 vssd1 X2_sky130_fd_sc_hd__fill_2
XFILLER_95_105 vssd1 vccd1 vccd1 vssd1 X2_sky130_fd_sc_hd__fill_4
XFILLER_49_500 vssd1 vccd1 vccd1 vssd1 X2_sky130_fd_sc_hd__fill_4
XFILLER_1_573 vssd1 vccd1 vssd1 vccd1 X2_sky130_ef_sc_hd__decap_40_12
XFILLER_3_69 vssd1 vccd1 vssd1 vccd1 X2_sky130_ef_sc_hd__decap_40_12
XFILLER_95_149 vssd1 vccd1 vssd1 vccd1 X2_sky130_ef_sc_hd__decap_40_12
XFILLER_49_544 vssd1 vccd1 vssd1 vccd1 X2_sky130_ef_sc_hd__decap_40_12
XFILLER_76_363 vccd1 vssd1 vccd1 vssd1 X2_sky130_fd_sc_hd__fill_1
XFILLER_64_514 vssd1 vccd1 vssd1 vccd1 X2_sky130_ef_sc_hd__decap_40_12
XFILLER_49_599 vssd1 vccd1 vssd1 vccd1 X2_sky130_ef_sc_hd__decap_40_12
XFILLER_49_588 vssd1 vccd1 vccd1 vssd1 X2_sky130_fd_sc_hd__fill_2
XTAP_TAPCELL_ROW_19_425 vccd1 vssd1 X2_sky130_fd_sc_hd__tapvpwrvgnd_1
XTAP_TAPCELL_ROW_47_734 vccd1 vssd1 X2_sky130_fd_sc_hd__tapvpwrvgnd_1
XFILLER_17_441 vssd1 vccd1 vccd1 vssd1 X2_sky130_fd_sc_hd__fill_4
X_628_ vssd1 vccd1 _628_/X _628_/A vccd1 vssd1 X2_sky130_fd_sc_hd__clkbuf_1
XFILLER_91_388 vssd1 vccd1 vccd1 vssd1 X2_sky130_fd_sc_hd__fill_4
XFILLER_17_485 vssd1 vccd1 vssd1 vccd1 X2_sky130_ef_sc_hd__decap_40_12
XFILLER_32_400 vssd1 vccd1 vssd1 vccd1 X2_sky130_ef_sc_hd__decap_40_12
XFILLER_83_93 vssd1 vccd1 vssd1 vccd1 X2_sky130_ef_sc_hd__decap_40_12
X_559_ vssd1 vccd1 vccd1 vssd1 _607_/CLK _559_/D _479_/Y _559_/Q X2_sky130_fd_sc_hd__dfrtp_1
XFILLER_32_477 vssd1 vccd1 vssd1 vccd1 X2_sky130_ef_sc_hd__decap_40_12
XFILLER_73_3 vssd1 vccd1 vssd1 vccd1 X2_sky130_ef_sc_hd__decap_40_12
XTAP_TAPCELL_ROW_74_1032 vccd1 vssd1 X2_sky130_fd_sc_hd__tapvpwrvgnd_1
XFILLER_87_617 vssd1 vccd1 vccd1 vssd1 X2_sky130_fd_sc_hd__fill_8
XFILLER_101_405 vssd1 vccd1 vccd1 vssd1 X2_sky130_fd_sc_hd__fill_2
XFILLER_101_449 vssd1 vccd1 vssd1 vccd1 X2_sky130_ef_sc_hd__decap_40_12
XFILLER_27_205 vssd1 vccd1 vssd1 vccd1 X2_sky130_ef_sc_hd__decap_40_12
XFILLER_67_385 vssd1 vccd1 vccd1 vssd1 X2_sky130_fd_sc_hd__fill_4
XFILLER_55_503 vccd1 vssd1 vccd1 vssd1 X2_sky130_fd_sc_hd__fill_1
XFILLER_27_249 vssd1 vccd1 vssd1 vccd1 X2_sky130_ef_sc_hd__decap_40_12
XFILLER_94_193 vssd1 vccd1 vccd1 vssd1 X2_sky130_fd_sc_hd__fill_2
XFILLER_82_333 vssd1 vccd1 vssd1 vccd1 X2_sky130_ef_sc_hd__decap_40_12
XTAP_TAPCELL_ROW_85_1150 vccd1 vssd1 X2_sky130_fd_sc_hd__tapvpwrvgnd_1
XFILLER_82_377 vssd1 vccd1 vssd1 vccd1 X2_sky130_ef_sc_hd__decap_40_12
XFILLER_35_293 vssd1 vccd1 vccd1 vssd1 X2_sky130_fd_sc_hd__fill_2
XFILLER_50_230 vssd1 vccd1 vssd1 vccd1 X2_sky130_ef_sc_hd__decap_40_12
XFILLER_11_617 vssd1 vccd1 vccd1 vssd1 X2_sky130_fd_sc_hd__fill_8
XFILLER_6_109 vssd1 vccd1 vssd1 vccd1 X2_sky130_ef_sc_hd__decap_40_12
XFILLER_88_27 vccd1 vssd1 vccd1 vssd1 X2_sky130_fd_sc_hd__fill_1
XANTENNA__511__A _527_/A vssd1 vccd1 vccd1 vssd1 X2_sky130_fd_sc_hd__diode_2
XFILLER_77_105 vssd1 vccd1 vccd1 vssd1 X2_sky130_fd_sc_hd__fill_4
XFILLER_93_609 vssd1 vccd1 vccd1 vssd1 X2_sky130_fd_sc_hd__fill_4
XFILLER_77_149 vssd1 vccd1 vssd1 vccd1 X2_sky130_ef_sc_hd__decap_40_12
XFILLER_58_363 vccd1 vssd1 vccd1 vssd1 X2_sky130_fd_sc_hd__fill_1
XFILLER_18_249 vssd1 vccd1 vccd1 vssd1 X2_sky130_fd_sc_hd__fill_2
XFILLER_85_193 vssd1 vccd1 vssd1 vccd1 X2_sky130_ef_sc_hd__decap_40_12
XFILLER_73_333 vssd1 vccd1 vccd1 vssd1 X2_sky130_fd_sc_hd__fill_2
XFILLER_61_517 vssd1 vccd1 vssd1 vccd1 X2_sky130_ef_sc_hd__decap_40_12
XTAP_TAPCELL_ROW_44_704 vccd1 vssd1 X2_sky130_fd_sc_hd__tapvpwrvgnd_1
X_413_ vssd1 vccd1 _413_/B _413_/Y _413_/A vccd1 vssd1 X2_sky130_fd_sc_hd__xnor2_1
XFILLER_14_433 vssd1 vccd1 vssd1 vccd1 X2_sky130_ef_sc_hd__decap_40_12
XFILLER_41_241 vssd1 vccd1 vssd1 vccd1 X2_sky130_ef_sc_hd__decap_40_12
XFILLER_14_477 vssd1 vccd1 vssd1 vccd1 X2_sky130_ef_sc_hd__decap_40_12
XTAP_TAPCELL_ROW_99_1308 vccd1 vssd1 X2_sky130_fd_sc_hd__tapvpwrvgnd_1
X_344_ vccd1 vssd1 vssd1 vccd1 _343_/X _317_/B hold15/X _342_/X _344_/X X2_sky130_fd_sc_hd__o22a_1
XTAP_TAPCELL_ROW_24_483 vccd1 vssd1 X2_sky130_fd_sc_hd__tapvpwrvgnd_1
X_275_ vssd1 vccd1 vccd1 vssd1 _604_/D hold11/X _289_/S _275_/A0 X2_sky130_fd_sc_hd__mux2_1
XTAP_TAPCELL_ROW_52_792 vccd1 vssd1 X2_sky130_fd_sc_hd__tapvpwrvgnd_1
XFILLER_69_617 vssd1 vccd1 vccd1 vssd1 X2_sky130_fd_sc_hd__fill_4
XFILLER_1_370 vssd1 vccd1 vssd1 vccd1 X2_sky130_ef_sc_hd__decap_40_12
XANTENNA__552__CLK _553_/CLK vssd1 vccd1 vccd1 vssd1 X2_sky130_fd_sc_hd__diode_2
XFILLER_96_469 vssd1 vccd1 vccd1 vssd1 X2_sky130_fd_sc_hd__fill_4
XFILLER_37_503 vccd1 vssd1 vccd1 vssd1 X2_sky130_fd_sc_hd__fill_1
XFILLER_37_536 vssd1 vccd1 vccd1 vssd1 X2_sky130_fd_sc_hd__fill_2
XFILLER_94_81 vssd1 vccd1 vccd1 vssd1 X2_sky130_fd_sc_hd__fill_2
XFILLER_76_193 vssd1 vccd1 vccd1 vssd1 X2_sky130_fd_sc_hd__fill_2
XFILLER_64_377 vssd1 vccd1 vccd1 vssd1 X2_sky130_fd_sc_hd__fill_2
XFILLER_17_293 vssd1 vccd1 vssd1 vccd1 X2_sky130_ef_sc_hd__decap_40_12
XFILLER_20_469 vssd1 vccd1 vccd1 vssd1 X2_sky130_fd_sc_hd__fill_4
XANTENNA__315__B _317_/B vssd1 vccd1 vccd1 vssd1 X2_sky130_fd_sc_hd__diode_2
XFILLER_101_202 vssd1 vccd1 vssd1 vccd1 X2_sky130_ef_sc_hd__decap_40_12
XFILLER_59_105 vssd1 vccd1 vccd1 vssd1 X2_sky130_fd_sc_hd__fill_4
XFILLER_87_447 vccd1 vssd1 vccd1 vssd1 X2_sky130_fd_sc_hd__fill_1
XFILLER_59_149 vssd1 vccd1 vssd1 vccd1 X2_sky130_ef_sc_hd__decap_40_12
XFILLER_101_268 vccd1 vssd1 vccd1 vssd1 X2_sky130_fd_sc_hd__fill_1
XPHY_EDGE_ROW_27_Left_129 vccd1 vssd1 vccd1 vssd1 X2_sky130_fd_sc_hd__decap_3
XFILLER_28_525 vssd1 vccd1 vccd1 vssd1 X2_sky130_fd_sc_hd__fill_4
Xclkbuf_3_5__f_wb_clk_i vssd1 vccd1 vssd1 vccd1 clkbuf_0_wb_clk_i/X _597_/CLK X2_sky130_fd_sc_hd__clkbuf_16
XFILLER_74_29 vssd1 vccd1 vssd1 vccd1 X2_sky130_ef_sc_hd__decap_40_12
XFILLER_67_193 vssd1 vccd1 vssd1 vccd1 X2_sky130_ef_sc_hd__decap_40_12
XFILLER_28_569 vssd1 vccd1 vssd1 vccd1 X2_sky130_ef_sc_hd__decap_40_12
XFILLER_82_141 vssd1 vccd1 vssd1 vccd1 X2_sky130_ef_sc_hd__decap_40_12
XFILLER_43_517 vssd1 vccd1 vccd1 vssd1 X2_sky130_fd_sc_hd__fill_2
XFILLER_43_539 vssd1 vccd1 vssd1 vccd1 X2_sky130_ef_sc_hd__decap_40_12
XFILLER_51_583 vssd1 vccd1 vccd1 vssd1 X2_sky130_fd_sc_hd__fill_4
XFILLER_51_561 vssd1 vccd1 vccd1 vssd1 X2_sky130_fd_sc_hd__fill_8
XFILLER_11_447 vccd1 vssd1 vccd1 vssd1 X2_sky130_fd_sc_hd__fill_1
XFILLER_23_55 vccd1 vssd1 vccd1 vssd1 X2_sky130_fd_sc_hd__fill_1
XANTENNA__506__A _517_/A vssd1 vccd1 vccd1 vssd1 X2_sky130_fd_sc_hd__diode_2
XFILLER_7_429 vssd1 vccd1 vssd1 vccd1 X2_sky130_ef_sc_hd__decap_40_12
XTAP_TAPCELL_ROW_21_453 vccd1 vssd1 X2_sky130_fd_sc_hd__tapvpwrvgnd_1
XPHY_EDGE_ROW_36_Left_138 vccd1 vssd1 vccd1 vssd1 X2_sky130_fd_sc_hd__decap_3
XFILLER_99_15 vssd1 vccd1 vssd1 vccd1 X2_sky130_ef_sc_hd__decap_40_12
XFILLER_3_613 vssd1 vccd1 vccd1 vssd1 X2_sky130_fd_sc_hd__fill_2
XTAP_TAPCELL_ROW_94_1249 vccd1 vssd1 X2_sky130_fd_sc_hd__tapvpwrvgnd_1
XFILLER_3_3 vssd1 vccd1 vssd1 vccd1 X2_sky130_ef_sc_hd__decap_40_12
XFILLER_2_189 vssd1 vccd1 vccd1 vssd1 X2_sky130_fd_sc_hd__fill_4
XFILLER_78_469 vssd1 vccd1 vccd1 vssd1 X2_sky130_fd_sc_hd__fill_4
XFILLER_66_609 vssd1 vccd1 vccd1 vssd1 X2_sky130_fd_sc_hd__fill_2
XFILLER_48_41 vssd1 vccd1 vssd1 vccd1 X2_sky130_ef_sc_hd__decap_40_12
XFILLER_19_503 vccd1 vssd1 vccd1 vssd1 X2_sky130_fd_sc_hd__fill_1
XFILLER_93_417 vssd1 vccd1 vssd1 vccd1 X2_sky130_ef_sc_hd__decap_40_12
XFILLER_48_85 vssd1 vccd1 vssd1 vccd1 X2_sky130_ef_sc_hd__decap_40_12
XPHY_EDGE_ROW_45_Left_147 vccd1 vssd1 vccd1 vssd1 X2_sky130_fd_sc_hd__decap_3
XFILLER_0_15 vssd1 vccd1 vssd1 vccd1 X2_sky130_ef_sc_hd__decap_40_12
XFILLER_58_193 vssd1 vccd1 vccd1 vssd1 X2_sky130_fd_sc_hd__fill_2
XTAP_TAPCELL_ROW_29_542 vccd1 vssd1 X2_sky130_fd_sc_hd__tapvpwrvgnd_1
XTAP_TAPCELL_ROW_57_851 vccd1 vssd1 X2_sky130_fd_sc_hd__tapvpwrvgnd_1
XFILLER_9_57 vssd1 vccd1 vssd1 vccd1 X2_sky130_ef_sc_hd__decap_40_12
X_327_ vccd1 vssd1 vccd1 vssd1 _320_/X _595_/Q _304_/A _327_/X _587_/Q X2_sky130_fd_sc_hd__a22o_1
XFILLER_80_83 vccd1 vssd1 vccd1 vssd1 X2_sky130_fd_sc_hd__fill_1
XPHY_EDGE_ROW_54_Left_156 vccd1 vssd1 vccd1 vssd1 X2_sky130_fd_sc_hd__decap_3
XFILLER_6_473 vssd1 vccd1 vccd1 vssd1 X2_sky130_fd_sc_hd__fill_2
XFILLER_89_81 vssd1 vccd1 vssd1 vccd1 X2_sky130_ef_sc_hd__decap_40_12
XTAP_TAPCELL_ROW_71_1002 vccd1 vssd1 X2_sky130_fd_sc_hd__tapvpwrvgnd_1
XFILLER_36_3 vssd1 vccd1 vssd1 vccd1 X2_sky130_ef_sc_hd__decap_40_12
XFILLER_96_233 vssd1 vccd1 vssd1 vccd1 X2_sky130_ef_sc_hd__decap_40_12
XFILLER_69_447 vccd1 vssd1 vccd1 vssd1 X2_sky130_fd_sc_hd__fill_1
XPHY_EDGE_ROW_63_Left_165 vccd1 vssd1 vccd1 vssd1 X2_sky130_fd_sc_hd__decap_3
XFILLER_37_300 vssd1 vccd1 vssd1 vccd1 X2_sky130_ef_sc_hd__decap_40_12
XFILLER_96_277 vssd1 vccd1 vccd1 vssd1 X2_sky130_fd_sc_hd__fill_4
XFILLER_84_417 vssd1 vccd1 vccd1 vssd1 X2_sky130_fd_sc_hd__fill_2
XFILLER_49_193 vssd1 vccd1 vssd1 vccd1 X2_sky130_ef_sc_hd__decap_40_12
XANTENNA__297__S _299_/S vssd1 vccd1 vccd1 vssd1 X2_sky130_fd_sc_hd__diode_2
XFILLER_80_601 vssd1 vccd1 vssd1 vccd1 X2_sky130_ef_sc_hd__decap_40_12
XFILLER_64_141 vssd1 vccd1 vssd1 vccd1 X2_sky130_ef_sc_hd__decap_40_12
XFILLER_25_517 vssd1 vccd1 vssd1 vccd1 X2_sky130_ef_sc_hd__decap_40_12
XFILLER_52_325 vssd1 vccd1 vccd1 vssd1 X2_sky130_fd_sc_hd__fill_2
XTAP_TAPCELL_ROW_82_1120 vccd1 vssd1 X2_sky130_fd_sc_hd__tapvpwrvgnd_1
XFILLER_33_561 vccd1 vssd1 vccd1 vssd1 X2_sky130_fd_sc_hd__fill_1
XFILLER_100_27 vccd1 vssd1 vccd1 vssd1 X2_sky130_fd_sc_hd__fill_1
XFILLER_20_233 vssd1 vccd1 vssd1 vccd1 X2_sky130_ef_sc_hd__decap_40_12
XPHY_EDGE_ROW_72_Left_174 vccd1 vssd1 vccd1 vssd1 X2_sky130_fd_sc_hd__decap_3
XANTENNA__598__CLK _599_/CLK vssd1 vccd1 vccd1 vssd1 X2_sky130_fd_sc_hd__diode_2
XFILLER_20_277 vssd1 vccd1 vssd1 vccd1 X2_sky130_ef_sc_hd__decap_40_12
XPHY_EDGE_ROW_81_Left_183 vccd1 vssd1 vccd1 vssd1 X2_sky130_fd_sc_hd__decap_3
XFILLER_87_277 vssd1 vccd1 vccd1 vssd1 X2_sky130_fd_sc_hd__fill_2
XFILLER_85_39 vssd1 vccd1 vssd1 vccd1 X2_sky130_ef_sc_hd__decap_40_12
XFILLER_75_417 vssd1 vccd1 vssd1 vccd1 X2_sky130_ef_sc_hd__decap_40_12
XFILLER_28_333 vssd1 vccd1 vssd1 vccd1 X2_sky130_ef_sc_hd__decap_40_12
XFILLER_18_77 vssd1 vccd1 vccd1 vssd1 X2_sky130_fd_sc_hd__fill_4
XFILLER_83_461 vssd1 vccd1 vssd1 vccd1 X2_sky130_ef_sc_hd__decap_40_12
XTAP_TAPCELL_ROW_26_501 vccd1 vssd1 X2_sky130_fd_sc_hd__tapvpwrvgnd_1
XFILLER_28_377 vssd1 vccd1 vssd1 vccd1 X2_sky130_ef_sc_hd__decap_40_12
XTAP_TAPCELL_ROW_54_810 vccd1 vssd1 X2_sky130_fd_sc_hd__tapvpwrvgnd_1
XFILLER_43_325 vssd1 vccd1 vccd1 vssd1 X2_sky130_fd_sc_hd__fill_8
XFILLER_70_133 vssd1 vccd1 vccd1 vssd1 X2_sky130_fd_sc_hd__fill_4
XPHY_EDGE_ROW_90_Left_192 vccd1 vssd1 vccd1 vssd1 X2_sky130_fd_sc_hd__decap_3
XFILLER_70_177 vssd1 vccd1 vssd1 vccd1 X2_sky130_ef_sc_hd__decap_40_12
XFILLER_34_65 vssd1 vccd1 vssd1 vccd1 X2_sky130_ef_sc_hd__decap_40_12
XFILLER_51_391 vccd1 vssd1 vccd1 vssd1 X2_sky130_fd_sc_hd__fill_1
XFILLER_7_237 vssd1 vccd1 vssd1 vccd1 X2_sky130_ef_sc_hd__decap_40_12
XFILLER_11_277 vssd1 vccd1 vccd1 vssd1 X2_sky130_fd_sc_hd__fill_2
XFILLER_50_53 vssd1 vccd1 vssd1 vccd1 X2_sky130_ef_sc_hd__decap_40_12
XFILLER_50_97 vssd1 vccd1 vssd1 vccd1 X2_sky130_ef_sc_hd__decap_40_12
XFILLER_59_51 vssd1 vccd1 vccd1 vssd1 X2_sky130_fd_sc_hd__fill_4
XFILLER_39_609 vssd1 vccd1 vccd1 vssd1 X2_sky130_fd_sc_hd__fill_2
XFILLER_78_233 vssd1 vccd1 vssd1 vccd1 X2_sky130_ef_sc_hd__decap_40_12
XFILLER_78_277 vssd1 vccd1 vssd1 vccd1 X2_sky130_ef_sc_hd__decap_40_12
XFILLER_66_417 vssd1 vccd1 vccd1 vssd1 X2_sky130_fd_sc_hd__fill_2
XTAP_TAPCELL_ROW_6_281 vccd1 vssd1 X2_sky130_fd_sc_hd__tapvpwrvgnd_1
XFILLER_93_225 vssd1 vccd1 vssd1 vccd1 X2_sky130_ef_sc_hd__decap_40_12
XFILLER_19_333 vssd1 vccd1 vccd1 vssd1 X2_sky130_fd_sc_hd__fill_2
XFILLER_46_141 vssd1 vccd1 vssd1 vccd1 X2_sky130_ef_sc_hd__decap_40_12
XFILLER_62_601 vssd1 vccd1 vccd1 vssd1 X2_sky130_fd_sc_hd__fill_2
XANTENNA_clkload6_A _606_/CLK vssd1 vccd1 vccd1 vssd1 X2_sky130_fd_sc_hd__diode_2
XFILLER_46_185 vssd1 vccd1 vccd1 vssd1 X2_sky130_fd_sc_hd__fill_4
XFILLER_61_111 vccd1 vssd1 vccd1 vssd1 X2_sky130_fd_sc_hd__fill_1
XFILLER_15_561 vssd1 vccd1 vssd1 vccd1 X2_sky130_ef_sc_hd__decap_40_12
XFILLER_30_531 vccd1 vssd1 vccd1 vssd1 X2_sky130_fd_sc_hd__fill_1
XFILLER_91_93 vssd1 vccd1 vssd1 vccd1 X2_sky130_ef_sc_hd__decap_40_12
XTAP_TAPCELL_ROW_60_879 vccd1 vssd1 X2_sky130_fd_sc_hd__tapvpwrvgnd_1
XFILLER_97_553 vssd1 vccd1 vccd1 vssd1 X2_sky130_fd_sc_hd__fill_4
XFILLER_69_277 vssd1 vccd1 vccd1 vssd1 X2_sky130_fd_sc_hd__fill_2
XFILLER_57_417 vssd1 vccd1 vssd1 vccd1 X2_sky130_ef_sc_hd__decap_40_12
XFILLER_97_597 vssd1 vccd1 vssd1 vccd1 X2_sky130_ef_sc_hd__decap_40_12
XTAP_TAPCELL_ROW_68_968 vccd1 vssd1 X2_sky130_fd_sc_hd__tapvpwrvgnd_1
XFILLER_65_461 vssd1 vccd1 vssd1 vccd1 X2_sky130_ef_sc_hd__decap_40_12
XFILLER_37_185 vssd1 vccd1 vssd1 vccd1 X2_sky130_ef_sc_hd__decap_40_12
XFILLER_52_133 vssd1 vccd1 vccd1 vssd1 X2_sky130_fd_sc_hd__fill_4
XFILLER_80_475 vccd1 vssd1 vccd1 vssd1 X2_sky130_fd_sc_hd__fill_1
XFILLER_52_177 vssd1 vccd1 vssd1 vccd1 X2_sky130_ef_sc_hd__decap_40_12
XFILLER_33_391 vccd1 vssd1 vccd1 vssd1 X2_sky130_fd_sc_hd__fill_1
XFILLER_21_553 vssd1 vccd1 vccd1 vssd1 X2_sky130_fd_sc_hd__fill_4
XFILLER_21_597 vssd1 vccd1 vssd1 vccd1 X2_sky130_ef_sc_hd__decap_40_12
XTAP_TAPCELL_ROW_91_1219 vccd1 vssd1 X2_sky130_fd_sc_hd__tapvpwrvgnd_1
XFILLER_88_531 vccd1 vssd1 vccd1 vssd1 X2_sky130_fd_sc_hd__fill_1
XFILLER_96_27 vccd1 vssd1 vccd1 vssd1 X2_sky130_fd_sc_hd__fill_1
XFILLER_0_457 vccd1 vssd1 vccd1 vssd1 X2_sky130_fd_sc_hd__fill_1
Xhold21 hold21/X _561_/Q vccd1 vssd1 vssd1 vccd1 X2_sky130_fd_sc_hd__dlygate4sd3_1
Xhold10 _572_/D _305_/X vccd1 vssd1 vssd1 vccd1 X2_sky130_fd_sc_hd__dlygate4sd3_1
Xhold32 hold32/X _592_/Q vccd1 vssd1 vssd1 vccd1 X2_sky130_fd_sc_hd__dlygate4sd3_1
Xhold65 _558_/D _340_/X vccd1 vssd1 vssd1 vccd1 X2_sky130_fd_sc_hd__dlygate4sd3_1
XFILLER_75_225 vssd1 vccd1 vssd1 vccd1 X2_sky130_ef_sc_hd__decap_40_12
Xhold43 _552_/D _537_/Q vccd1 vssd1 vssd1 vccd1 X2_sky130_fd_sc_hd__dlygate4sd3_1
Xhold54 _584_/D _445_/X vccd1 vssd1 vssd1 vccd1 X2_sky130_fd_sc_hd__dlygate4sd3_1
XTAP_TAPCELL_ROW_3_251 vccd1 vssd1 X2_sky130_fd_sc_hd__tapvpwrvgnd_1
XFILLER_28_141 vssd1 vccd1 vssd1 vccd1 X2_sky130_ef_sc_hd__decap_40_12
Xhold76 hold76/X _577_/Q vccd1 vssd1 vssd1 vccd1 X2_sky130_fd_sc_hd__dlygate4sd3_1
Xhold87 hold1/A _542_/Q vccd1 vssd1 vssd1 vccd1 X2_sky130_fd_sc_hd__dlygate4sd3_1
X_592_ vssd1 vccd1 vccd1 vssd1 _607_/CLK _592_/D _512_/Y _592_/Q X2_sky130_fd_sc_hd__dfrtp_1
XFILLER_43_111 vccd1 vssd1 vccd1 vssd1 X2_sky130_fd_sc_hd__fill_1
XTAP_TAPCELL_ROW_100_1315 vccd1 vssd1 X2_sky130_fd_sc_hd__tapvpwrvgnd_1
XFILLER_71_497 vssd1 vccd1 vccd1 vssd1 X2_sky130_fd_sc_hd__fill_4
XFILLER_43_199 vssd1 vccd1 vssd1 vccd1 X2_sky130_ef_sc_hd__decap_40_12
XFILLER_8_513 vssd1 vccd1 vssd1 vccd1 X2_sky130_ef_sc_hd__decap_40_12
XFILLER_12_531 vccd1 vssd1 vccd1 vssd1 X2_sky130_fd_sc_hd__fill_1
XFILLER_101_81 vssd1 vccd1 vccd1 vssd1 X2_sky130_fd_sc_hd__fill_2
XFILLER_8_557 vssd1 vccd1 vssd1 vccd1 X2_sky130_ef_sc_hd__decap_40_12
XFILLER_3_273 vssd1 vccd1 vccd1 vssd1 X2_sky130_fd_sc_hd__fill_4
XFILLER_39_417 vssd1 vccd1 vssd1 vccd1 X2_sky130_ef_sc_hd__decap_40_12
XFILLER_94_501 vssd1 vccd1 vssd1 vccd1 X2_sky130_ef_sc_hd__decap_40_12
XFILLER_79_553 vssd1 vccd1 vccd1 vssd1 X2_sky130_fd_sc_hd__fill_4
XFILLER_94_545 vssd1 vccd1 vssd1 vccd1 X2_sky130_ef_sc_hd__decap_40_12
XFILLER_79_597 vssd1 vccd1 vssd1 vccd1 X2_sky130_ef_sc_hd__decap_40_12
XTAP_TAPCELL_ROW_37_629 vccd1 vssd1 X2_sky130_fd_sc_hd__tapvpwrvgnd_1
XFILLER_94_589 vssd1 vccd1 vssd1 vccd1 X2_sky130_ef_sc_hd__decap_40_12
XFILLER_81_217 vssd1 vccd1 vccd1 vssd1 X2_sky130_fd_sc_hd__fill_4
XTAP_TAPCELL_ROW_65_938 vccd1 vssd1 X2_sky130_fd_sc_hd__tapvpwrvgnd_1
XFILLER_34_133 vssd1 vccd1 vccd1 vssd1 X2_sky130_fd_sc_hd__fill_4
XFILLER_62_475 vccd1 vssd1 vccd1 vssd1 X2_sky130_fd_sc_hd__fill_1
XFILLER_50_615 vssd1 vccd1 vccd1 vssd1 X2_sky130_fd_sc_hd__fill_4
XFILLER_34_177 vssd1 vccd1 vssd1 vccd1 X2_sky130_ef_sc_hd__decap_40_12
XFILLER_15_391 vccd1 vssd1 vccd1 vssd1 X2_sky130_fd_sc_hd__fill_1
XTAP_TAPCELL_ROW_77_1063 vccd1 vssd1 X2_sky130_fd_sc_hd__tapvpwrvgnd_1
XFILLER_89_317 vssd1 vccd1 vccd1 vssd1 X2_sky130_fd_sc_hd__fill_2
XANTENNA__286__A0 _446_/A1 vssd1 vccd1 vccd1 vssd1 X2_sky130_fd_sc_hd__diode_2
XFILLER_85_501 vssd1 vccd1 vccd1 vssd1 X2_sky130_fd_sc_hd__fill_2
XFILLER_57_225 vssd1 vccd1 vssd1 vccd1 X2_sky130_ef_sc_hd__decap_40_12
XTAP_TAPCELL_ROW_0_210 vccd1 vssd1 X2_sky130_fd_sc_hd__tapvpwrvgnd_1
XTAP_TAPCELL_ROW_0_221 vccd1 vssd1 X2_sky130_fd_sc_hd__tapvpwrvgnd_1
XFILLER_26_601 vssd1 vccd1 vssd1 vccd1 X2_sky130_ef_sc_hd__decap_40_12
XFILLER_25_111 vccd1 vssd1 vccd1 vssd1 X2_sky130_fd_sc_hd__fill_1
XTAP_TAPCELL_ROW_88_1192 vccd1 vssd1 X2_sky130_fd_sc_hd__tapvpwrvgnd_1
XFILLER_82_29 vssd1 vccd1 vssd1 vccd1 X2_sky130_ef_sc_hd__decap_40_12
XFILLER_53_442 vssd1 vccd1 vccd1 vssd1 X2_sky130_fd_sc_hd__fill_2
XFILLER_41_615 vccd1 vssd1 vccd1 vssd1 X2_sky130_fd_sc_hd__fill_1
XFILLER_13_317 vssd1 vccd1 vssd1 vccd1 X2_sky130_ef_sc_hd__decap_40_12
XFILLER_21_361 vssd1 vccd1 vssd1 vccd1 X2_sky130_ef_sc_hd__decap_40_12
XFILLER_5_505 vssd1 vccd1 vssd1 vccd1 X2_sky130_ef_sc_hd__decap_40_12
XANTENNA__514__A _517_/A vssd1 vccd1 vccd1 vssd1 X2_sky130_fd_sc_hd__diode_2
XFILLER_31_55 vccd1 vssd1 vccd1 vssd1 X2_sky130_fd_sc_hd__fill_1
XTAP_TAPCELL_ROW_8_310 vccd1 vssd1 X2_sky130_fd_sc_hd__tapvpwrvgnd_1
Xoutput55 vccd1 vssd1 wbs_dat_o[6] _563_/Q vccd1 vssd1 X2_sky130_fd_sc_hd__buf_2
Xoutput44 vccd1 vssd1 wbs_dat_o[10] _567_/Q vccd1 vssd1 X2_sky130_fd_sc_hd__buf_2
XFILLER_76_501 vssd1 vccd1 vssd1 vccd1 X2_sky130_ef_sc_hd__decap_40_12
XFILLER_0_265 vssd1 vccd1 vccd1 vssd1 X2_sky130_fd_sc_hd__fill_4
XFILLER_76_545 vssd1 vccd1 vssd1 vccd1 X2_sky130_ef_sc_hd__decap_40_12
XANTENNA_input23_A wbs_dat_i[0] vssd1 vccd1 vccd1 vssd1 X2_sky130_fd_sc_hd__diode_2
XFILLER_56_41 vssd1 vccd1 vssd1 vccd1 X2_sky130_ef_sc_hd__decap_40_12
XFILLER_29_461 vssd1 vccd1 vssd1 vccd1 X2_sky130_ef_sc_hd__decap_40_12
XFILLER_76_589 vssd1 vccd1 vssd1 vccd1 X2_sky130_ef_sc_hd__decap_40_12
XFILLER_91_559 vccd1 vssd1 vccd1 vssd1 X2_sky130_fd_sc_hd__fill_1
XFILLER_56_280 vssd1 vccd1 vssd1 vccd1 X2_sky130_ef_sc_hd__decap_40_12
XFILLER_56_85 vssd1 vccd1 vssd1 vccd1 X2_sky130_ef_sc_hd__decap_40_12
XFILLER_16_133 vssd1 vccd1 vccd1 vssd1 X2_sky130_fd_sc_hd__fill_4
XFILLER_44_475 vccd1 vssd1 vccd1 vssd1 X2_sky130_fd_sc_hd__fill_1
X_575_ vccd1 vssd1 vccd1 vssd1 _575_/Q _495_/Y _575_/D _609_/CLK X2_sky130_fd_sc_hd__dfstp_1
XFILLER_16_177 vssd1 vccd1 vssd1 vccd1 X2_sky130_ef_sc_hd__decap_40_12
XFILLER_31_125 vssd1 vccd1 vssd1 vccd1 X2_sky130_ef_sc_hd__decap_40_12
XFILLER_71_261 vssd1 vccd1 vssd1 vccd1 X2_sky130_ef_sc_hd__decap_40_12
XFILLER_44_486 vssd1 vccd1 vccd1 vssd1 X2_sky130_fd_sc_hd__fill_2
XFILLER_8_321 vssd1 vccd1 vssd1 vccd1 X2_sky130_ef_sc_hd__decap_40_12
XFILLER_12_361 vssd1 vccd1 vccd1 vssd1 X2_sky130_fd_sc_hd__fill_2
XTAP_TAPCELL_ROW_14_378 vccd1 vssd1 X2_sky130_fd_sc_hd__tapvpwrvgnd_1
XFILLER_31_169 vssd1 vccd1 vssd1 vccd1 X2_sky130_ef_sc_hd__decap_40_12
XTAP_TAPCELL_ROW_70_985 vccd1 vssd1 X2_sky130_fd_sc_hd__tapvpwrvgnd_1
XTAP_TAPCELL_ROW_42_687 vccd1 vssd1 X2_sky130_fd_sc_hd__tapvpwrvgnd_1
XFILLER_8_365 vssd1 vccd1 vssd1 vccd1 X2_sky130_ef_sc_hd__decap_40_12
XFILLER_99_615 vccd1 vssd1 vccd1 vssd1 X2_sky130_fd_sc_hd__fill_1
XFILLER_97_81 vssd1 vccd1 vssd1 vccd1 X2_sky130_ef_sc_hd__decap_40_12
XFILLER_86_309 vssd1 vccd1 vssd1 vccd1 X2_sky130_ef_sc_hd__decap_40_12
XFILLER_79_361 vssd1 vccd1 vssd1 vccd1 X2_sky130_ef_sc_hd__decap_40_12
XFILLER_67_501 vssd1 vccd1 vccd1 vssd1 X2_sky130_fd_sc_hd__fill_2
XFILLER_39_225 vssd1 vccd1 vssd1 vccd1 X2_sky130_ef_sc_hd__decap_40_12
XFILLER_67_589 vssd1 vccd1 vccd1 vssd1 X2_sky130_fd_sc_hd__fill_2
XFILLER_23_615 vccd1 vssd1 vccd1 vssd1 X2_sky130_fd_sc_hd__fill_1
XFILLER_35_442 vssd1 vccd1 vccd1 vssd1 X2_sky130_fd_sc_hd__fill_4
XFILLER_35_486 vssd1 vccd1 vssd1 vccd1 X2_sky130_ef_sc_hd__decap_40_12
XFILLER_90_581 vssd1 vccd1 vccd1 vssd1 X2_sky130_fd_sc_hd__fill_4
XFILLER_10_309 vssd1 vccd1 vssd1 vccd1 X2_sky130_ef_sc_hd__decap_40_12
XFILLER_89_125 vssd1 vccd1 vssd1 vccd1 X2_sky130_ef_sc_hd__decap_40_12
XFILLER_89_169 vssd1 vccd1 vssd1 vccd1 X2_sky130_ef_sc_hd__decap_40_12
XFILLER_58_501 vssd1 vccd1 vssd1 vccd1 X2_sky130_ef_sc_hd__decap_40_12
XFILLER_58_545 vssd1 vccd1 vssd1 vccd1 X2_sky130_ef_sc_hd__decap_40_12
XFILLER_93_39 vssd1 vccd1 vssd1 vccd1 X2_sky130_ef_sc_hd__decap_40_12
XFILLER_58_589 vccd1 vssd1 vccd1 vssd1 X2_sky130_fd_sc_hd__fill_1
XFILLER_73_559 vccd1 vssd1 vccd1 vssd1 X2_sky130_fd_sc_hd__fill_1
XFILLER_45_228 vssd1 vccd1 vccd1 vssd1 X2_sky130_fd_sc_hd__fill_2
XFILLER_60_209 vssd1 vccd1 vssd1 vccd1 X2_sky130_ef_sc_hd__decap_40_12
XANTENNA__509__A _517_/A vssd1 vccd1 vccd1 vssd1 X2_sky130_fd_sc_hd__diode_2
XFILLER_26_77 vssd1 vccd1 vccd1 vssd1 X2_sky130_fd_sc_hd__fill_4
XFILLER_26_475 vccd1 vssd1 vccd1 vssd1 X2_sky130_fd_sc_hd__fill_1
X_360_ _360_/X _535_/Q _550_/Q vssd1 vccd1 vccd1 vssd1 X2_sky130_fd_sc_hd__and2b_1
XFILLER_13_125 vssd1 vccd1 vssd1 vccd1 X2_sky130_ef_sc_hd__decap_40_12
XFILLER_41_445 vssd1 vccd1 vccd1 vssd1 X2_sky130_fd_sc_hd__fill_2
XFILLER_13_169 vssd1 vccd1 vssd1 vccd1 X2_sky130_ef_sc_hd__decap_40_12
X_291_ vccd1 vssd1 vssd1 vccd1 _291_/B _299_/S _291_/A X2_sky130_fd_sc_hd__nand2_4
XTAP_TAPCELL_ROW_11_337 vccd1 vssd1 X2_sky130_fd_sc_hd__tapvpwrvgnd_1
XFILLER_42_65 vssd1 vccd1 vssd1 vccd1 X2_sky130_ef_sc_hd__decap_40_12
XFILLER_5_335 vccd1 vssd1 vccd1 vssd1 X2_sky130_fd_sc_hd__fill_1
XFILLER_1_541 vssd1 vccd1 vssd1 vccd1 X2_sky130_ef_sc_hd__decap_40_12
XFILLER_3_15 vssd1 vccd1 vssd1 vccd1 X2_sky130_ef_sc_hd__decap_40_12
XFILLER_68_309 vssd1 vccd1 vccd1 vssd1 X2_sky130_fd_sc_hd__fill_8
XFILLER_1_585 vssd1 vccd1 vssd1 vccd1 X2_sky130_ef_sc_hd__decap_40_12
XFILLER_49_556 vssd1 vccd1 vccd1 vssd1 X2_sky130_fd_sc_hd__fill_4
XFILLER_64_526 vssd1 vccd1 vccd1 vssd1 X2_sky130_fd_sc_hd__fill_4
XTAP_TAPCELL_ROW_19_426 vccd1 vssd1 X2_sky130_fd_sc_hd__tapvpwrvgnd_1
XFILLER_29_291 vccd1 vssd1 vccd1 vssd1 X2_sky130_fd_sc_hd__fill_1
XTAP_TAPCELL_ROW_47_735 vccd1 vssd1 X2_sky130_fd_sc_hd__tapvpwrvgnd_1
XFILLER_44_250 vssd1 vccd1 vccd1 vssd1 X2_sky130_fd_sc_hd__fill_2
XFILLER_17_497 vssd1 vccd1 vccd1 vssd1 X2_sky130_fd_sc_hd__fill_4
XFILLER_32_412 vssd1 vccd1 vccd1 vssd1 X2_sky130_fd_sc_hd__fill_8
XFILLER_72_581 vssd1 vccd1 vccd1 vssd1 X2_sky130_fd_sc_hd__fill_4
X_558_ vssd1 vccd1 vccd1 vssd1 _608_/CLK _558_/D _478_/Y _558_/Q X2_sky130_fd_sc_hd__dfrtp_1
XFILLER_32_489 vssd1 vccd1 vssd1 vccd1 X2_sky130_ef_sc_hd__decap_40_12
X_489_ vccd1 vssd1 vccd1 vssd1 _489_/Y _525_/A X2_sky130_fd_sc_hd__inv_2
XFILLER_8_195 vccd1 vssd1 vccd1 vssd1 X2_sky130_fd_sc_hd__fill_1
XFILLER_66_3 vccd1 vssd1 vccd1 vssd1 X2_sky130_fd_sc_hd__fill_1
XTAP_TAPCELL_ROW_74_1033 vccd1 vssd1 X2_sky130_fd_sc_hd__tapvpwrvgnd_1
XFILLER_59_309 vssd1 vccd1 vccd1 vssd1 X2_sky130_fd_sc_hd__fill_2
XFILLER_101_417 vssd1 vccd1 vccd1 vssd1 X2_sky130_fd_sc_hd__fill_2
XFILLER_86_139 vccd1 vssd1 vccd1 vssd1 X2_sky130_fd_sc_hd__fill_1
XFILLER_27_217 vssd1 vccd1 vccd1 vssd1 X2_sky130_fd_sc_hd__fill_4
XFILLER_82_301 vssd1 vccd1 vccd1 vssd1 X2_sky130_fd_sc_hd__fill_4
Xclkbuf_3_4__f_wb_clk_i vssd1 vccd1 vssd1 vccd1 clkbuf_0_wb_clk_i/X _609_/CLK X2_sky130_fd_sc_hd__clkbuf_16
XFILLER_82_345 vssd1 vccd1 vssd1 vccd1 X2_sky130_ef_sc_hd__decap_40_12
XFILLER_55_559 vccd1 vssd1 vccd1 vssd1 X2_sky130_fd_sc_hd__fill_1
XTAP_TAPCELL_ROW_85_1151 vccd1 vssd1 X2_sky130_fd_sc_hd__tapvpwrvgnd_1
XFILLER_82_389 vssd1 vccd1 vssd1 vccd1 X2_sky130_ef_sc_hd__decap_40_12
XFILLER_70_529 vssd1 vccd1 vccd1 vssd1 X2_sky130_fd_sc_hd__fill_2
XFILLER_23_445 vssd1 vccd1 vccd1 vssd1 X2_sky130_fd_sc_hd__fill_2
XFILLER_50_242 vssd1 vccd1 vccd1 vssd1 X2_sky130_fd_sc_hd__fill_4
XFILLER_50_253 vssd1 vccd1 vssd1 vccd1 X2_sky130_ef_sc_hd__decap_40_12
XFILLER_10_139 vccd1 vssd1 vccd1 vssd1 X2_sky130_fd_sc_hd__fill_1
XFILLER_2_305 vssd1 vccd1 vccd1 vssd1 X2_sky130_fd_sc_hd__fill_2
XTAP_TAPCELL_ROW_96_1280 vccd1 vssd1 X2_sky130_fd_sc_hd__tapvpwrvgnd_1
XFILLER_92_109 vssd1 vccd1 vssd1 vccd1 X2_sky130_ef_sc_hd__decap_40_12
XFILLER_85_161 vssd1 vccd1 vccd1 vssd1 X2_sky130_fd_sc_hd__fill_4
XTAP_TAPCELL_ROW_44_705 vccd1 vssd1 X2_sky130_fd_sc_hd__tapvpwrvgnd_1
XFILLER_14_401 vssd1 vccd1 vssd1 vccd1 X2_sky130_ef_sc_hd__decap_40_12
XFILLER_73_389 vssd1 vccd1 vccd1 vssd1 X2_sky130_fd_sc_hd__fill_2
XFILLER_61_529 vssd1 vccd1 vssd1 vccd1 X2_sky130_ef_sc_hd__decap_40_12
X_412_ vccd1 vssd1 vssd1 vccd1 _360_/X _362_/X _359_/Y _413_/B X2_sky130_fd_sc_hd__o21a_1
XFILLER_14_445 vssd1 vccd1 vssd1 vccd1 X2_sky130_ef_sc_hd__decap_40_12
XFILLER_14_489 vssd1 vccd1 vssd1 vccd1 X2_sky130_ef_sc_hd__decap_40_12
XFILLER_41_253 vssd1 vccd1 vssd1 vccd1 X2_sky130_ef_sc_hd__decap_40_12
X_343_ vccd1 vssd1 vccd1 vssd1 _590_/Q _304_/A _343_/X _291_/B _574_/Q _341_/X X2_sky130_fd_sc_hd__a221o_1
XTAP_TAPCELL_ROW_24_484 vccd1 vssd1 X2_sky130_fd_sc_hd__tapvpwrvgnd_1
XTAP_TAPCELL_ROW_99_1309 vccd1 vssd1 X2_sky130_fd_sc_hd__tapvpwrvgnd_1
X_274_ vssd1 vccd1 vccd1 vssd1 _605_/D hold9/X _289_/S _274_/A0 X2_sky130_fd_sc_hd__mux2_1
XTAP_TAPCELL_ROW_52_793 vccd1 vssd1 X2_sky130_fd_sc_hd__tapvpwrvgnd_1
XFILLER_5_165 vssd1 vccd1 vccd1 vssd1 X2_sky130_fd_sc_hd__fill_2
XFILLER_78_83 vccd1 vssd1 vccd1 vssd1 X2_sky130_fd_sc_hd__fill_1
XFILLER_1_382 vssd1 vccd1 vccd1 vssd1 X2_sky130_fd_sc_hd__fill_8
XFILLER_1_393 vssd1 vccd1 vssd1 vccd1 X2_sky130_ef_sc_hd__decap_40_12
XFILLER_68_139 vccd1 vssd1 vccd1 vssd1 X2_sky130_fd_sc_hd__fill_1
XFILLER_83_109 vssd1 vccd1 vccd1 vssd1 X2_sky130_fd_sc_hd__fill_2
XFILLER_37_526 vssd1 vccd1 vccd1 vssd1 X2_sky130_fd_sc_hd__fill_2
XFILLER_24_209 vssd1 vccd1 vssd1 vccd1 X2_sky130_ef_sc_hd__decap_40_12
XFILLER_37_559 vccd1 vssd1 vccd1 vssd1 X2_sky130_fd_sc_hd__fill_1
XFILLER_17_261 vssd1 vccd1 vssd1 vccd1 X2_sky130_ef_sc_hd__decap_40_12
XFILLER_32_253 vssd1 vccd1 vssd1 vccd1 X2_sky130_ef_sc_hd__decap_40_12
XANTENNA__315__C _317_/C vssd1 vccd1 vccd1 vssd1 X2_sky130_fd_sc_hd__diode_2
XFILLER_101_214 vssd1 vccd1 vccd1 vssd1 X2_sky130_fd_sc_hd__fill_8
XFILLER_101_225 vssd1 vccd1 vssd1 vccd1 X2_sky130_ef_sc_hd__decap_40_12
XFILLER_101_258 vssd1 vccd1 vccd1 vssd1 X2_sky130_fd_sc_hd__fill_2
XFILLER_74_109 vssd1 vccd1 vssd1 vccd1 X2_sky130_ef_sc_hd__decap_40_12
XFILLER_67_161 vssd1 vccd1 vccd1 vssd1 X2_sky130_fd_sc_hd__fill_4
XFILLER_82_153 vssd1 vccd1 vssd1 vccd1 X2_sky130_ef_sc_hd__decap_40_12
XFILLER_43_507 vccd1 vssd1 vccd1 vssd1 X2_sky130_fd_sc_hd__fill_1
XFILLER_55_389 vssd1 vccd1 vccd1 vssd1 X2_sky130_fd_sc_hd__fill_2
XFILLER_82_197 vssd1 vccd1 vssd1 vccd1 X2_sky130_ef_sc_hd__decap_40_12
XFILLER_90_29 vssd1 vccd1 vssd1 vccd1 X2_sky130_ef_sc_hd__decap_40_12
XFILLER_51_595 vssd1 vccd1 vssd1 vccd1 X2_sky130_ef_sc_hd__decap_40_12
XTAP_TAPCELL_ROW_21_454 vccd1 vssd1 X2_sky130_fd_sc_hd__tapvpwrvgnd_1
XFILLER_99_27 vssd1 vccd1 vssd1 vccd1 X2_sky130_ef_sc_hd__decap_40_12
XANTENNA__522__A _525_/A vssd1 vccd1 vccd1 vssd1 X2_sky130_fd_sc_hd__diode_2
XFILLER_93_429 vssd1 vccd1 vssd1 vccd1 X2_sky130_ef_sc_hd__decap_40_12
XFILLER_65_109 vssd1 vccd1 vccd1 vssd1 X2_sky130_fd_sc_hd__fill_2
XFILLER_48_53 vssd1 vccd1 vssd1 vccd1 X2_sky130_ef_sc_hd__decap_40_12
XPHY_EDGE_ROW_100_Left_202 vccd1 vssd1 vccd1 vssd1 X2_sky130_fd_sc_hd__decap_3
XFILLER_48_97 vssd1 vccd1 vssd1 vccd1 X2_sky130_ef_sc_hd__decap_40_12
XFILLER_0_27 vccd1 vssd1 vccd1 vssd1 X2_sky130_fd_sc_hd__fill_1
XFILLER_19_559 vccd1 vssd1 vccd1 vssd1 X2_sky130_fd_sc_hd__fill_1
XTAP_TAPCELL_ROW_29_543 vccd1 vssd1 X2_sky130_fd_sc_hd__tapvpwrvgnd_1
XTAP_TAPCELL_ROW_57_852 vccd1 vssd1 X2_sky130_fd_sc_hd__tapvpwrvgnd_1
XFILLER_64_41 vssd1 vccd1 vssd1 vccd1 X2_sky130_ef_sc_hd__decap_40_12
XFILLER_46_389 vssd1 vccd1 vccd1 vssd1 X2_sky130_fd_sc_hd__fill_8
XFILLER_64_85 vssd1 vccd1 vssd1 vccd1 X2_sky130_ef_sc_hd__decap_40_12
XFILLER_61_337 vssd1 vccd1 vccd1 vssd1 X2_sky130_fd_sc_hd__fill_2
XFILLER_14_253 vssd1 vccd1 vssd1 vccd1 X2_sky130_ef_sc_hd__decap_40_12
XFILLER_9_69 vssd1 vccd1 vssd1 vccd1 X2_sky130_ef_sc_hd__decap_40_12
X_326_ vccd1 vssd1 vccd1 vssd1 _579_/Q _291_/B _326_/X _317_/C _535_/Q _303_/X X2_sky130_fd_sc_hd__a221o_1
XFILLER_89_93 vssd1 vccd1 vssd1 vccd1 X2_sky130_ef_sc_hd__decap_40_12
XTAP_TAPCELL_ROW_71_1003 vccd1 vssd1 X2_sky130_fd_sc_hd__tapvpwrvgnd_1
XFILLER_96_245 vssd1 vccd1 vccd1 vssd1 X2_sky130_fd_sc_hd__fill_4
XFILLER_29_3 vssd1 vccd1 vssd1 vccd1 X2_sky130_ef_sc_hd__decap_40_12
XFILLER_56_109 vssd1 vccd1 vssd1 vccd1 X2_sky130_ef_sc_hd__decap_40_12
XFILLER_37_312 vssd1 vccd1 vssd1 vccd1 X2_sky130_ef_sc_hd__decap_40_12
XFILLER_49_161 vssd1 vccd1 vccd1 vssd1 X2_sky130_fd_sc_hd__fill_4
XFILLER_37_367 vssd1 vccd1 vccd1 vssd1 X2_sky130_fd_sc_hd__fill_2
XFILLER_25_529 vssd1 vccd1 vssd1 vccd1 X2_sky130_ef_sc_hd__decap_40_12
XFILLER_37_378 vssd1 vccd1 vccd1 vssd1 X2_sky130_fd_sc_hd__fill_2
XFILLER_92_473 vssd1 vccd1 vccd1 vssd1 X2_sky130_fd_sc_hd__fill_2
XFILLER_80_613 vssd1 vccd1 vssd1 vccd1 X2_sky130_ef_sc_hd__decap_40_12
XFILLER_64_153 vssd1 vccd1 vssd1 vccd1 X2_sky130_ef_sc_hd__decap_40_12
XFILLER_18_581 vssd1 vccd1 vccd1 vssd1 X2_sky130_fd_sc_hd__fill_4
XTAP_TAPCELL_ROW_82_1121 vccd1 vssd1 X2_sky130_fd_sc_hd__tapvpwrvgnd_1
XFILLER_64_197 vssd1 vccd1 vssd1 vccd1 X2_sky130_ef_sc_hd__decap_40_12
XFILLER_20_245 vssd1 vccd1 vccd1 vssd1 X2_sky130_fd_sc_hd__fill_4
XFILLER_20_289 vssd1 vccd1 vssd1 vccd1 X2_sky130_ef_sc_hd__decap_40_12
XFILLER_0_617 vssd1 vccd1 vccd1 vssd1 X2_sky130_fd_sc_hd__fill_8
XFILLER_87_223 vccd1 vssd1 vccd1 vssd1 X2_sky130_fd_sc_hd__fill_1
XFILLER_47_109 vssd1 vccd1 vccd1 vssd1 X2_sky130_fd_sc_hd__fill_2
XFILLER_75_429 vssd1 vccd1 vssd1 vccd1 X2_sky130_ef_sc_hd__decap_40_12
XFILLER_28_345 vssd1 vccd1 vssd1 vccd1 X2_sky130_ef_sc_hd__decap_40_12
XFILLER_16_529 vssd1 vccd1 vccd1 vssd1 X2_sky130_fd_sc_hd__fill_2
XTAP_TAPCELL_ROW_26_502 vccd1 vssd1 X2_sky130_fd_sc_hd__tapvpwrvgnd_1
XFILLER_28_389 vssd1 vccd1 vssd1 vccd1 X2_sky130_ef_sc_hd__decap_40_12
XFILLER_83_473 vssd1 vccd1 vssd1 vccd1 X2_sky130_ef_sc_hd__decap_40_12
XFILLER_71_624 vccd1 vssd1 vccd1 vssd1 X2_sky130_fd_sc_hd__fill_1
XFILLER_71_613 vssd1 vccd1 vccd1 vssd1 X2_sky130_fd_sc_hd__fill_2
XTAP_TAPCELL_ROW_54_811 vccd1 vssd1 X2_sky130_fd_sc_hd__tapvpwrvgnd_1
XFILLER_43_315 vssd1 vccd1 vccd1 vssd1 X2_sky130_fd_sc_hd__fill_2
XFILLER_43_337 vssd1 vccd1 vssd1 vccd1 X2_sky130_ef_sc_hd__decap_40_12
XANTENNA__517__A _517_/A vssd1 vccd1 vccd1 vssd1 X2_sky130_fd_sc_hd__diode_2
XFILLER_11_223 vccd1 vssd1 vccd1 vssd1 X2_sky130_fd_sc_hd__fill_1
XFILLER_34_77 vssd1 vccd1 vccd1 vssd1 X2_sky130_fd_sc_hd__fill_4
XFILLER_70_189 vssd1 vccd1 vccd1 vssd1 X2_sky130_fd_sc_hd__fill_4
XFILLER_7_205 vssd1 vccd1 vssd1 vccd1 X2_sky130_ef_sc_hd__decap_40_12
XTAP_TAPCELL_ROW_34_590 vccd1 vssd1 X2_sky130_fd_sc_hd__tapvpwrvgnd_1
XFILLER_7_249 vssd1 vccd1 vssd1 vccd1 X2_sky130_ef_sc_hd__decap_40_12
XFILLER_50_65 vssd1 vccd1 vssd1 vccd1 X2_sky130_ef_sc_hd__decap_40_12
XFILLER_78_245 vssd1 vccd1 vccd1 vssd1 X2_sky130_fd_sc_hd__fill_4
XFILLER_38_109 vssd1 vccd1 vssd1 vccd1 X2_sky130_ef_sc_hd__decap_40_12
XTAP_TAPCELL_ROW_6_282 vccd1 vssd1 X2_sky130_fd_sc_hd__tapvpwrvgnd_1
XFILLER_93_237 vssd1 vccd1 vssd1 vccd1 X2_sky130_ef_sc_hd__decap_40_12
XFILLER_78_289 vssd1 vccd1 vssd1 vccd1 X2_sky130_ef_sc_hd__decap_40_12
XFILLER_75_51 vssd1 vccd1 vccd1 vssd1 X2_sky130_fd_sc_hd__fill_4
XFILLER_19_389 vssd1 vccd1 vccd1 vssd1 X2_sky130_fd_sc_hd__fill_2
XFILLER_74_473 vssd1 vccd1 vccd1 vssd1 X2_sky130_fd_sc_hd__fill_2
XFILLER_62_624 vccd1 vssd1 vccd1 vssd1 X2_sky130_fd_sc_hd__fill_1
XFILLER_62_613 vssd1 vccd1 vccd1 vssd1 X2_sky130_fd_sc_hd__fill_2
XFILLER_46_153 vssd1 vccd1 vssd1 vccd1 X2_sky130_ef_sc_hd__decap_40_12
XFILLER_34_337 vssd1 vccd1 vccd1 vssd1 X2_sky130_fd_sc_hd__fill_4
XFILLER_34_359 vssd1 vccd1 vccd1 vssd1 X2_sky130_fd_sc_hd__fill_2
XFILLER_46_197 vccd1 vssd1 vccd1 vssd1 X2_sky130_fd_sc_hd__fill_1
XFILLER_61_167 vccd1 vssd1 vccd1 vssd1 X2_sky130_fd_sc_hd__fill_1
XFILLER_15_573 vssd1 vccd1 vssd1 vccd1 X2_sky130_ef_sc_hd__decap_40_12
XFILLER_30_587 vccd1 vssd1 vccd1 vssd1 X2_sky130_fd_sc_hd__fill_1
X_309_ vccd1 vssd1 vccd1 vssd1 _309_/C _270_/B _440_/B _309_/A _309_/B X2_sky130_fd_sc_hd__or4b_2
XFILLER_69_223 vccd1 vssd1 vccd1 vssd1 X2_sky130_fd_sc_hd__fill_1
XFILLER_29_109 vssd1 vccd1 vccd1 vssd1 X2_sky130_fd_sc_hd__fill_2
XFILLER_57_429 vssd1 vccd1 vssd1 vccd1 X2_sky130_ef_sc_hd__decap_40_12
XTAP_TAPCELL_ROW_68_969 vccd1 vssd1 X2_sky130_fd_sc_hd__tapvpwrvgnd_1
XFILLER_1_81 vssd1 vccd1 vssd1 vccd1 X2_sky130_ef_sc_hd__decap_40_12
XFILLER_65_473 vssd1 vccd1 vccd1 vssd1 X2_sky130_fd_sc_hd__fill_2
XFILLER_53_624 vccd1 vssd1 vccd1 vssd1 X2_sky130_fd_sc_hd__fill_1
XFILLER_25_337 vssd1 vccd1 vssd1 vccd1 X2_sky130_ef_sc_hd__decap_40_12
XFILLER_37_197 vssd1 vccd1 vssd1 vccd1 X2_sky130_ef_sc_hd__decap_40_12
XANTENNA__565__CLK _599_/CLK vssd1 vccd1 vccd1 vssd1 X2_sky130_fd_sc_hd__diode_2
XFILLER_80_421 vssd1 vccd1 vssd1 vccd1 X2_sky130_ef_sc_hd__decap_40_12
XFILLER_40_307 vccd1 vssd1 vccd1 vssd1 X2_sky130_fd_sc_hd__fill_1
XFILLER_40_318 vssd1 vccd1 vssd1 vccd1 X2_sky130_ef_sc_hd__decap_40_12
XFILLER_52_189 vssd1 vccd1 vccd1 vssd1 X2_sky130_fd_sc_hd__fill_4
XTAP_TAPCELL_ROW_31_560 vccd1 vssd1 X2_sky130_fd_sc_hd__tapvpwrvgnd_1
XFILLER_0_447 vccd1 vssd1 vccd1 vssd1 X2_sky130_fd_sc_hd__fill_1
Xhold22 _561_/D _331_/X vccd1 vssd1 vssd1 vccd1 X2_sky130_fd_sc_hd__dlygate4sd3_1
Xhold11 hold11/X _604_/Q vccd1 vssd1 vssd1 vccd1 X2_sky130_fd_sc_hd__dlygate4sd3_1
XFILLER_29_55 vccd1 vssd1 vccd1 vssd1 X2_sky130_fd_sc_hd__fill_1
XFILLER_29_621 vccd1 vssd1 vccd1 vssd1 X2_sky130_fd_sc_hd__fill_1
Xhold44 _549_/D _534_/Q vccd1 vssd1 vssd1 vccd1 X2_sky130_fd_sc_hd__dlygate4sd3_1
XFILLER_88_587 vccd1 vssd1 vccd1 vssd1 X2_sky130_fd_sc_hd__fill_1
XFILLER_75_237 vssd1 vccd1 vssd1 vccd1 X2_sky130_ef_sc_hd__decap_40_12
Xhold33 _556_/D _541_/Q vccd1 vssd1 vssd1 vccd1 X2_sky130_fd_sc_hd__dlygate4sd3_1
Xhold55 hold55/X _582_/Q vccd1 vssd1 vssd1 vccd1 X2_sky130_fd_sc_hd__dlygate4sd3_1
XTAP_TAPCELL_ROW_3_252 vccd1 vssd1 X2_sky130_fd_sc_hd__tapvpwrvgnd_1
Xhold66 hold66/X _598_/Q vccd1 vssd1 vssd1 vccd1 X2_sky130_fd_sc_hd__dlygate4sd3_1
Xhold88 hold2/A _543_/Q vccd1 vssd1 vssd1 vccd1 X2_sky130_fd_sc_hd__dlygate4sd3_1
Xhold77 hold77/X _576_/Q vccd1 vssd1 vssd1 vccd1 X2_sky130_fd_sc_hd__dlygate4sd3_1
XFILLER_28_153 vssd1 vccd1 vssd1 vccd1 X2_sky130_ef_sc_hd__decap_40_12
XFILLER_56_473 vssd1 vccd1 vccd1 vssd1 X2_sky130_fd_sc_hd__fill_2
XFILLER_44_624 vccd1 vssd1 vccd1 vssd1 X2_sky130_fd_sc_hd__fill_1
X_591_ vssd1 vccd1 vccd1 vssd1 _609_/CLK _591_/D _511_/Y _591_/Q X2_sky130_fd_sc_hd__dfrtp_1
XFILLER_28_197 vssd1 vccd1 vssd1 vccd1 X2_sky130_ef_sc_hd__decap_40_12
XFILLER_83_281 vssd1 vccd1 vssd1 vccd1 X2_sky130_ef_sc_hd__decap_40_12
XFILLER_43_167 vccd1 vssd1 vccd1 vssd1 X2_sky130_fd_sc_hd__fill_1
XTAP_TAPCELL_ROW_100_1316 vccd1 vssd1 X2_sky130_fd_sc_hd__tapvpwrvgnd_1
XFILLER_43_189 vssd1 vccd1 vccd1 vssd1 X2_sky130_fd_sc_hd__fill_2
XFILLER_8_525 vssd1 vccd1 vccd1 vssd1 X2_sky130_fd_sc_hd__fill_4
XFILLER_12_587 vccd1 vssd1 vccd1 vssd1 X2_sky130_fd_sc_hd__fill_1
XFILLER_6_15 vssd1 vccd1 vssd1 vccd1 X2_sky130_ef_sc_hd__decap_40_12
XFILLER_8_569 vssd1 vccd1 vssd1 vccd1 X2_sky130_ef_sc_hd__decap_40_12
XFILLER_98_307 vccd1 vssd1 vccd1 vssd1 X2_sky130_fd_sc_hd__fill_1
XFILLER_39_429 vssd1 vccd1 vssd1 vccd1 X2_sky130_ef_sc_hd__decap_40_12
XFILLER_94_513 vssd1 vccd1 vssd1 vccd1 X2_sky130_ef_sc_hd__decap_40_12
XFILLER_86_83 vccd1 vssd1 vccd1 vssd1 X2_sky130_fd_sc_hd__fill_1
XFILLER_94_557 vssd1 vccd1 vssd1 vccd1 X2_sky130_ef_sc_hd__decap_40_12
XFILLER_47_440 vssd1 vccd1 vccd1 vssd1 X2_sky130_fd_sc_hd__fill_8
XFILLER_35_624 vccd1 vssd1 vccd1 vssd1 X2_sky130_fd_sc_hd__fill_1
XTAP_TAPCELL_ROW_65_939 vccd1 vssd1 X2_sky130_fd_sc_hd__tapvpwrvgnd_1
XFILLER_62_421 vssd1 vccd1 vssd1 vccd1 X2_sky130_ef_sc_hd__decap_40_12
XFILLER_22_307 vccd1 vssd1 vccd1 vssd1 X2_sky130_fd_sc_hd__fill_1
XFILLER_50_605 vssd1 vccd1 vccd1 vssd1 X2_sky130_fd_sc_hd__fill_4
XFILLER_34_189 vssd1 vccd1 vccd1 vssd1 X2_sky130_fd_sc_hd__fill_4
XFILLER_96_3 vssd1 vccd1 vssd1 vccd1 X2_sky130_ef_sc_hd__decap_40_12
XFILLER_30_362 vssd1 vccd1 vccd1 vssd1 X2_sky130_fd_sc_hd__fill_2
XTAP_TAPCELL_ROW_77_1064 vccd1 vssd1 X2_sky130_fd_sc_hd__tapvpwrvgnd_1
XFILLER_97_351 vssd1 vccd1 vccd1 vssd1 X2_sky130_fd_sc_hd__fill_2
XFILLER_85_557 vssd1 vccd1 vccd1 vssd1 X2_sky130_fd_sc_hd__fill_2
XFILLER_57_237 vssd1 vccd1 vssd1 vccd1 X2_sky130_ef_sc_hd__decap_40_12
XTAP_TAPCELL_ROW_0_211 vccd1 vssd1 X2_sky130_fd_sc_hd__tapvpwrvgnd_1
XFILLER_26_613 vssd1 vccd1 vssd1 vccd1 X2_sky130_ef_sc_hd__decap_40_12
XTAP_TAPCELL_ROW_0_222 vccd1 vssd1 X2_sky130_fd_sc_hd__tapvpwrvgnd_1
XTAP_TAPCELL_ROW_88_1193 vccd1 vssd1 X2_sky130_fd_sc_hd__tapvpwrvgnd_1
XFILLER_65_292 vccd1 vssd1 vccd1 vssd1 X2_sky130_fd_sc_hd__fill_1
XFILLER_65_281 vccd1 vssd1 vccd1 vssd1 X2_sky130_fd_sc_hd__fill_1
XFILLER_53_421 vccd1 vssd1 vccd1 vssd1 X2_sky130_fd_sc_hd__fill_1
XFILLER_25_167 vccd1 vssd1 vccd1 vssd1 X2_sky130_fd_sc_hd__fill_1
XFILLER_80_251 vccd1 vssd1 vccd1 vssd1 X2_sky130_fd_sc_hd__fill_1
XFILLER_13_329 vssd1 vccd1 vccd1 vssd1 X2_sky130_fd_sc_hd__fill_4
XFILLER_15_57 vssd1 vccd1 vssd1 vccd1 X2_sky130_ef_sc_hd__decap_40_12
XFILLER_40_137 vssd1 vccd1 vccd1 vssd1 X2_sky130_fd_sc_hd__fill_2
XFILLER_21_373 vssd1 vccd1 vssd1 vccd1 X2_sky130_ef_sc_hd__decap_40_12
XFILLER_5_517 vssd1 vccd1 vssd1 vccd1 X2_sky130_ef_sc_hd__decap_40_12
XTAP_TAPCELL_ROW_8_311 vccd1 vssd1 X2_sky130_fd_sc_hd__tapvpwrvgnd_1
XFILLER_0_200 vssd1 vccd1 vssd1 vccd1 X2_sky130_ef_sc_hd__decap_40_12
Xoutput45 vccd1 vssd1 wbs_dat_o[11] _568_/Q vccd1 vssd1 X2_sky130_fd_sc_hd__buf_2
Xoutput56 vccd1 vssd1 wbs_dat_o[7] _564_/Q vccd1 vssd1 X2_sky130_fd_sc_hd__buf_2
XFILLER_76_513 vssd1 vccd1 vssd1 vccd1 X2_sky130_ef_sc_hd__decap_40_12
XFILLER_76_557 vssd1 vccd1 vssd1 vccd1 X2_sky130_ef_sc_hd__decap_40_12
XFILLER_17_613 vssd1 vccd1 vccd1 vssd1 X2_sky130_fd_sc_hd__fill_2
XFILLER_29_473 vssd1 vccd1 vssd1 vccd1 X2_sky130_ef_sc_hd__decap_40_12
XFILLER_91_505 vssd1 vccd1 vssd1 vccd1 X2_sky130_ef_sc_hd__decap_40_12
XFILLER_63_218 vssd1 vccd1 vccd1 vssd1 X2_sky130_fd_sc_hd__fill_2
XANTENNA_input16_A wbs_adr_i[2] vssd1 vccd1 vccd1 vssd1 X2_sky130_fd_sc_hd__diode_2
XFILLER_56_53 vssd1 vccd1 vssd1 vccd1 X2_sky130_ef_sc_hd__decap_40_12
XFILLER_56_292 vssd1 vccd1 vssd1 vccd1 X2_sky130_ef_sc_hd__decap_40_12
XFILLER_56_97 vssd1 vccd1 vssd1 vccd1 X2_sky130_ef_sc_hd__decap_40_12
XFILLER_44_421 vccd1 vssd1 vccd1 vssd1 X2_sky130_fd_sc_hd__fill_1
X_574_ vccd1 vssd1 vccd1 vssd1 _574_/Q _494_/Y _574_/D _607_/CLK X2_sky130_fd_sc_hd__dfstp_1
XFILLER_44_465 vssd1 vccd1 vccd1 vssd1 X2_sky130_fd_sc_hd__fill_2
XFILLER_16_189 vssd1 vccd1 vccd1 vssd1 X2_sky130_fd_sc_hd__fill_4
XFILLER_32_616 vssd1 vccd1 vccd1 vssd1 X2_sky130_fd_sc_hd__fill_2
XFILLER_72_41 vssd1 vccd1 vssd1 vccd1 X2_sky130_ef_sc_hd__decap_40_12
XFILLER_71_273 vssd1 vccd1 vccd1 vssd1 X2_sky130_fd_sc_hd__fill_4
XFILLER_31_137 vssd1 vccd1 vssd1 vccd1 X2_sky130_ef_sc_hd__decap_40_12
XFILLER_72_85 vssd1 vccd1 vssd1 vccd1 X2_sky130_ef_sc_hd__decap_40_12
XTAP_TAPCELL_ROW_14_379 vccd1 vssd1 X2_sky130_fd_sc_hd__tapvpwrvgnd_1
XTAP_TAPCELL_ROW_70_986 vccd1 vssd1 X2_sky130_fd_sc_hd__tapvpwrvgnd_1
XTAP_TAPCELL_ROW_42_677 vccd1 vssd1 X2_sky130_fd_sc_hd__tapvpwrvgnd_1
XFILLER_8_333 vssd1 vccd1 vssd1 vccd1 X2_sky130_ef_sc_hd__decap_40_12
XFILLER_8_377 vssd1 vccd1 vssd1 vccd1 X2_sky130_ef_sc_hd__decap_40_12
XFILLER_98_137 vssd1 vccd1 vccd1 vssd1 X2_sky130_fd_sc_hd__fill_2
XFILLER_97_93 vssd1 vccd1 vssd1 vccd1 X2_sky130_ef_sc_hd__decap_40_12
XFILLER_100_109 vssd1 vccd1 vssd1 vccd1 X2_sky130_ef_sc_hd__decap_40_12
Xclkbuf_3_3__f_wb_clk_i vssd1 vccd1 vssd1 vccd1 clkbuf_0_wb_clk_i/X _599_/CLK X2_sky130_fd_sc_hd__clkbuf_16
XFILLER_79_373 vssd1 vccd1 vssd1 vccd1 X2_sky130_ef_sc_hd__decap_40_12
XFILLER_11_3 vssd1 vccd1 vssd1 vccd1 X2_sky130_ef_sc_hd__decap_40_12
XFILLER_39_237 vssd1 vccd1 vssd1 vccd1 X2_sky130_ef_sc_hd__decap_40_12
XFILLER_94_321 vssd1 vccd1 vssd1 vccd1 X2_sky130_ef_sc_hd__decap_40_12
XFILLER_67_557 vssd1 vccd1 vccd1 vssd1 X2_sky130_fd_sc_hd__fill_2
XFILLER_94_365 vssd1 vccd1 vssd1 vccd1 X2_sky130_ef_sc_hd__decap_40_12
XFILLER_47_281 vccd1 vssd1 vccd1 vssd1 X2_sky130_fd_sc_hd__fill_1
XFILLER_35_465 vssd1 vccd1 vccd1 vssd1 X2_sky130_fd_sc_hd__fill_2
XFILLER_62_251 vccd1 vssd1 vccd1 vssd1 X2_sky130_fd_sc_hd__fill_1
XFILLER_35_476 vssd1 vccd1 vccd1 vssd1 X2_sky130_fd_sc_hd__fill_2
XFILLER_35_498 vssd1 vccd1 vccd1 vssd1 X2_sky130_fd_sc_hd__fill_4
XFILLER_22_137 vssd1 vccd1 vccd1 vssd1 X2_sky130_fd_sc_hd__fill_2
XANTENNA__603__CLK _606_/CLK vssd1 vccd1 vccd1 vssd1 X2_sky130_fd_sc_hd__diode_2
XFILLER_89_137 vssd1 vccd1 vssd1 vccd1 X2_sky130_ef_sc_hd__decap_40_12
XFILLER_58_513 vssd1 vccd1 vssd1 vccd1 X2_sky130_ef_sc_hd__decap_40_12
XANTENNA_input8_A adc_data_in[5] vssd1 vccd1 vccd1 vssd1 X2_sky130_fd_sc_hd__diode_2
XFILLER_97_181 vssd1 vccd1 vssd1 vccd1 X2_sky130_ef_sc_hd__decap_40_12
XFILLER_85_332 vssd1 vccd1 vccd1 vssd1 X2_sky130_fd_sc_hd__fill_4
XFILLER_58_557 vssd1 vccd1 vssd1 vccd1 X2_sky130_ef_sc_hd__decap_40_12
XFILLER_73_505 vssd1 vccd1 vssd1 vccd1 X2_sky130_ef_sc_hd__decap_40_12
XFILLER_26_421 vssd1 vccd1 vssd1 vccd1 X2_sky130_ef_sc_hd__decap_40_12
XFILLER_38_281 vssd1 vccd1 vccd1 vssd1 X2_sky130_fd_sc_hd__fill_2
XFILLER_38_292 vssd1 vccd1 vssd1 vccd1 X2_sky130_ef_sc_hd__decap_40_12
XANTENNA__431__A1 _547_/D vssd1 vccd1 vccd1 vssd1 X2_sky130_fd_sc_hd__diode_2
XFILLER_13_137 vssd1 vccd1 vssd1 vccd1 X2_sky130_ef_sc_hd__decap_40_12
X_290_ vssd1 vccd1 vssd1 vccd1 _320_/B _291_/B _320_/A _341_/C _320_/C X2_sky130_fd_sc_hd__and4b_4
XFILLER_42_11 vssd1 vccd1 vssd1 vccd1 X2_sky130_ef_sc_hd__decap_40_12
XANTENNA__525__A _525_/A vssd1 vccd1 vccd1 vssd1 X2_sky130_fd_sc_hd__diode_2
XTAP_TAPCELL_ROW_11_338 vccd1 vssd1 X2_sky130_fd_sc_hd__tapvpwrvgnd_1
XFILLER_21_181 vssd1 vccd1 vssd1 vccd1 X2_sky130_ef_sc_hd__decap_40_12
XFILLER_42_77 vssd1 vccd1 vccd1 vssd1 X2_sky130_fd_sc_hd__fill_4
XFILLER_1_553 vssd1 vccd1 vccd1 vssd1 X2_sky130_fd_sc_hd__fill_4
XFILLER_3_27 vssd1 vccd1 vssd1 vccd1 X2_sky130_ef_sc_hd__decap_40_12
XFILLER_1_597 vssd1 vccd1 vssd1 vccd1 X2_sky130_ef_sc_hd__decap_40_12
XFILLER_76_321 vssd1 vccd1 vssd1 vccd1 X2_sky130_ef_sc_hd__decap_40_12
XFILLER_76_365 vssd1 vccd1 vssd1 vccd1 X2_sky130_ef_sc_hd__decap_40_12
XTAP_TAPCELL_ROW_19_427 vccd1 vssd1 X2_sky130_fd_sc_hd__tapvpwrvgnd_1
XFILLER_29_281 vssd1 vccd1 vccd1 vssd1 X2_sky130_fd_sc_hd__fill_8
XFILLER_36_229 vssd1 vccd1 vccd1 vssd1 X2_sky130_fd_sc_hd__fill_2
XFILLER_91_313 vssd1 vccd1 vccd1 vssd1 X2_sky130_fd_sc_hd__fill_2
XFILLER_91_335 vccd1 vssd1 vccd1 vssd1 X2_sky130_fd_sc_hd__fill_1
XTAP_TAPCELL_ROW_47_736 vccd1 vssd1 X2_sky130_fd_sc_hd__tapvpwrvgnd_1
XFILLER_83_51 vssd1 vccd1 vccd1 vssd1 X2_sky130_fd_sc_hd__fill_4
X_557_ vssd1 vccd1 vccd1 vssd1 _597_/CLK _557_/D _477_/Y _557_/Q X2_sky130_fd_sc_hd__dfrtp_1
X_488_ vccd1 vssd1 vccd1 vssd1 _488_/Y _521_/A X2_sky130_fd_sc_hd__inv_2
XFILLER_8_141 vssd1 vccd1 vssd1 vccd1 X2_sky130_ef_sc_hd__decap_40_12
XFILLER_59_3 vssd1 vccd1 vssd1 vccd1 X2_sky130_ef_sc_hd__decap_40_12
XFILLER_99_435 vssd1 vccd1 vccd1 vssd1 X2_sky130_fd_sc_hd__fill_2
XTAP_TAPCELL_ROW_74_1034 vccd1 vssd1 X2_sky130_fd_sc_hd__tapvpwrvgnd_1
XFILLER_101_429 vccd1 vssd1 vccd1 vssd1 X2_sky130_fd_sc_hd__fill_1
XFILLER_79_181 vssd1 vccd1 vssd1 vccd1 X2_sky130_ef_sc_hd__decap_40_12
XFILLER_55_505 vssd1 vccd1 vssd1 vccd1 X2_sky130_ef_sc_hd__decap_40_12
XFILLER_94_195 vccd1 vssd1 vccd1 vssd1 X2_sky130_fd_sc_hd__fill_1
XFILLER_82_357 vssd1 vccd1 vccd1 vssd1 X2_sky130_fd_sc_hd__fill_4
XTAP_TAPCELL_ROW_85_1152 vccd1 vssd1 X2_sky130_fd_sc_hd__tapvpwrvgnd_1
XFILLER_35_295 vccd1 vssd1 vccd1 vssd1 X2_sky130_fd_sc_hd__fill_1
XFILLER_50_265 vssd1 vccd1 vssd1 vccd1 X2_sky130_ef_sc_hd__decap_40_12
XFILLER_88_29 vssd1 vccd1 vssd1 vccd1 X2_sky130_ef_sc_hd__decap_40_12
XTAP_TAPCELL_ROW_96_1281 vccd1 vssd1 X2_sky130_fd_sc_hd__tapvpwrvgnd_1
XFILLER_58_365 vssd1 vccd1 vssd1 vccd1 X2_sky130_ef_sc_hd__decap_40_12
XFILLER_37_55 vccd1 vssd1 vccd1 vssd1 X2_sky130_fd_sc_hd__fill_1
XFILLER_100_473 vssd1 vccd1 vccd1 vssd1 X2_sky130_fd_sc_hd__fill_2
XFILLER_73_335 vccd1 vssd1 vccd1 vssd1 X2_sky130_fd_sc_hd__fill_1
XFILLER_14_413 vssd1 vccd1 vccd1 vssd1 X2_sky130_fd_sc_hd__fill_4
XFILLER_26_251 vccd1 vssd1 vccd1 vssd1 X2_sky130_fd_sc_hd__fill_1
X_411_ vssd1 vccd1 _411_/B _411_/Y _411_/A vccd1 vssd1 X2_sky130_fd_sc_hd__xnor2_1
XTAP_TAPCELL_ROW_44_706 vccd1 vssd1 X2_sky130_fd_sc_hd__tapvpwrvgnd_1
XFILLER_14_457 vssd1 vccd1 vssd1 vccd1 X2_sky130_ef_sc_hd__decap_40_12
XFILLER_41_265 vssd1 vccd1 vssd1 vccd1 X2_sky130_ef_sc_hd__decap_40_12
X_342_ vccd1 vssd1 vccd1 vssd1 hold5/X _317_/C _342_/X _320_/X _582_/Q _303_/X X2_sky130_fd_sc_hd__a221o_1
XTAP_TAPCELL_ROW_24_485 vccd1 vssd1 X2_sky130_fd_sc_hd__tapvpwrvgnd_1
XTAP_TAPCELL_ROW_52_794 vccd1 vssd1 X2_sky130_fd_sc_hd__tapvpwrvgnd_1
X_273_ vccd1 vssd1 vssd1 vccd1 _320_/B _291_/A _440_/A _341_/B X2_sky130_fd_sc_hd__nand3_1
XFILLER_41_298 vssd1 vccd1 vccd1 vssd1 X2_sky130_fd_sc_hd__fill_2
XFILLER_6_601 vssd1 vccd1 vssd1 vccd1 X2_sky130_ef_sc_hd__decap_40_12
XFILLER_5_111 vccd1 vssd1 vccd1 vssd1 X2_sky130_fd_sc_hd__fill_1
XFILLER_69_608 vssd1 vccd1 vccd1 vssd1 X2_sky130_fd_sc_hd__fill_8
XFILLER_37_505 vccd1 vssd1 vccd1 vssd1 X2_sky130_fd_sc_hd__fill_1
XFILLER_37_549 vssd1 vccd1 vccd1 vssd1 X2_sky130_fd_sc_hd__fill_2
XFILLER_64_324 vssd1 vccd1 vssd1 vccd1 X2_sky130_ef_sc_hd__decap_40_12
XFILLER_64_313 vssd1 vccd1 vccd1 vssd1 X2_sky130_fd_sc_hd__fill_2
XFILLER_94_83 vccd1 vssd1 vccd1 vssd1 X2_sky130_fd_sc_hd__fill_1
XFILLER_76_195 vccd1 vssd1 vccd1 vssd1 X2_sky130_fd_sc_hd__fill_1
XFILLER_17_273 vssd1 vccd1 vccd1 vssd1 X2_sky130_fd_sc_hd__fill_4
XFILLER_91_165 vssd1 vccd1 vccd1 vssd1 X2_sky130_fd_sc_hd__fill_2
X_609_ vssd1 vccd1 vccd1 vssd1 _609_/CLK hold2/X _529_/Y _609_/Q X2_sky130_fd_sc_hd__dfrtp_1
XFILLER_32_265 vssd1 vccd1 vssd1 vccd1 X2_sky130_ef_sc_hd__decap_40_12
XFILLER_60_585 vssd1 vccd1 vccd1 vssd1 X2_sky130_fd_sc_hd__fill_2
XFILLER_9_461 vssd1 vccd1 vssd1 vccd1 X2_sky130_ef_sc_hd__decap_40_12
XFILLER_99_221 vssd1 vccd1 vccd1 vssd1 X2_sky130_fd_sc_hd__fill_2
XFILLER_87_405 vssd1 vccd1 vssd1 vccd1 X2_sky130_ef_sc_hd__decap_40_12
XFILLER_4_81 vssd1 vccd1 vccd1 vssd1 X2_sky130_fd_sc_hd__fill_2
XFILLER_87_449 vssd1 vccd1 vssd1 vccd1 X2_sky130_ef_sc_hd__decap_40_12
XFILLER_101_237 vssd1 vccd1 vssd1 vccd1 X2_sky130_ef_sc_hd__decap_40_12
XFILLER_82_121 vssd1 vccd1 vssd1 vccd1 X2_sky130_ef_sc_hd__decap_40_12
XFILLER_82_165 vssd1 vccd1 vssd1 vccd1 X2_sky130_ef_sc_hd__decap_40_12
XFILLER_70_305 vssd1 vccd1 vccd1 vssd1 X2_sky130_fd_sc_hd__fill_2
XFILLER_23_221 vssd1 vccd1 vccd1 vssd1 X2_sky130_fd_sc_hd__fill_2
XFILLER_51_541 vssd1 vccd1 vssd1 vccd1 X2_sky130_ef_sc_hd__decap_40_12
XFILLER_11_405 vssd1 vccd1 vssd1 vccd1 X2_sky130_ef_sc_hd__decap_40_12
XFILLER_11_449 vssd1 vccd1 vssd1 vccd1 X2_sky130_ef_sc_hd__decap_40_12
XFILLER_23_57 vssd1 vccd1 vssd1 vccd1 X2_sky130_ef_sc_hd__decap_40_12
XTAP_TAPCELL_ROW_21_455 vccd1 vssd1 X2_sky130_fd_sc_hd__tapvpwrvgnd_1
XFILLER_99_39 vssd1 vccd1 vssd1 vccd1 X2_sky130_ef_sc_hd__decap_40_12
XFILLER_3_615 vccd1 vssd1 vccd1 vssd1 X2_sky130_fd_sc_hd__fill_1
XFILLER_19_505 vssd1 vccd1 vssd1 vccd1 X2_sky130_ef_sc_hd__decap_40_12
XFILLER_48_65 vssd1 vccd1 vssd1 vccd1 X2_sky130_ef_sc_hd__decap_40_12
XTAP_TAPCELL_ROW_29_544 vccd1 vssd1 X2_sky130_fd_sc_hd__tapvpwrvgnd_1
XFILLER_58_195 vccd1 vssd1 vccd1 vssd1 X2_sky130_fd_sc_hd__fill_1
XTAP_TAPCELL_ROW_57_842 vccd1 vssd1 X2_sky130_fd_sc_hd__tapvpwrvgnd_1
XFILLER_34_519 vssd1 vccd1 vssd1 vccd1 X2_sky130_ef_sc_hd__decap_40_12
XFILLER_73_165 vssd1 vccd1 vccd1 vssd1 X2_sky130_fd_sc_hd__fill_2
XFILLER_64_53 vssd1 vccd1 vssd1 vccd1 X2_sky130_ef_sc_hd__decap_40_12
XFILLER_61_327 vssd1 vccd1 vccd1 vssd1 X2_sky130_fd_sc_hd__fill_2
XFILLER_61_305 vssd1 vccd1 vccd1 vssd1 X2_sky130_fd_sc_hd__fill_4
XFILLER_14_221 vssd1 vccd1 vssd1 vccd1 X2_sky130_ef_sc_hd__decap_40_12
XFILLER_64_97 vssd1 vccd1 vssd1 vccd1 X2_sky130_ef_sc_hd__decap_40_12
XFILLER_9_15 vssd1 vccd1 vssd1 vccd1 X2_sky130_ef_sc_hd__decap_40_12
XFILLER_14_265 vssd1 vccd1 vssd1 vccd1 X2_sky130_ef_sc_hd__decap_40_12
X_325_ vccd1 vssd1 vssd1 vccd1 _324_/X _317_/B hold61/X _323_/X _325_/X X2_sky130_fd_sc_hd__o22a_1
XFILLER_80_41 vssd1 vccd1 vssd1 vccd1 X2_sky130_ef_sc_hd__decap_40_12
XFILLER_80_85 vssd1 vccd1 vssd1 vccd1 X2_sky130_ef_sc_hd__decap_40_12
XFILLER_6_475 vccd1 vssd1 vccd1 vssd1 X2_sky130_fd_sc_hd__fill_1
XTAP_TAPCELL_ROW_71_1004 vccd1 vssd1 X2_sky130_fd_sc_hd__tapvpwrvgnd_1
XFILLER_69_405 vssd1 vccd1 vssd1 vccd1 X2_sky130_ef_sc_hd__decap_40_12
XFILLER_69_449 vssd1 vccd1 vssd1 vccd1 X2_sky130_ef_sc_hd__decap_40_12
XFILLER_84_419 vccd1 vssd1 vccd1 vssd1 X2_sky130_fd_sc_hd__fill_1
XFILLER_37_324 vssd1 vccd1 vssd1 vccd1 X2_sky130_ef_sc_hd__decap_40_12
XFILLER_37_346 vssd1 vccd1 vccd1 vssd1 X2_sky130_fd_sc_hd__fill_2
XFILLER_64_121 vssd1 vccd1 vssd1 vccd1 X2_sky130_ef_sc_hd__decap_40_12
XFILLER_64_165 vssd1 vccd1 vssd1 vccd1 X2_sky130_ef_sc_hd__decap_40_12
XTAP_TAPCELL_ROW_82_1122 vccd1 vssd1 X2_sky130_fd_sc_hd__tapvpwrvgnd_1
XFILLER_100_29 vssd1 vccd1 vssd1 vccd1 X2_sky130_ef_sc_hd__decap_40_12
XTAP_TAPCELL_ROW_93_1240 vccd1 vssd1 X2_sky130_fd_sc_hd__tapvpwrvgnd_1
XFILLER_87_279 vccd1 vssd1 vccd1 vssd1 X2_sky130_fd_sc_hd__fill_1
XFILLER_28_357 vssd1 vccd1 vccd1 vssd1 X2_sky130_fd_sc_hd__fill_4
XFILLER_83_441 vssd1 vccd1 vccd1 vssd1 X2_sky130_fd_sc_hd__fill_4
XTAP_TAPCELL_ROW_26_503 vccd1 vssd1 X2_sky130_fd_sc_hd__tapvpwrvgnd_1
XFILLER_83_485 vssd1 vccd1 vssd1 vccd1 X2_sky130_ef_sc_hd__decap_40_12
XFILLER_55_165 vssd1 vccd1 vccd1 vssd1 X2_sky130_fd_sc_hd__fill_2
XTAP_TAPCELL_ROW_54_812 vccd1 vssd1 X2_sky130_fd_sc_hd__tapvpwrvgnd_1
XFILLER_43_305 vssd1 vccd1 vccd1 vssd1 X2_sky130_fd_sc_hd__fill_8
XFILLER_43_349 vssd1 vccd1 vccd1 vssd1 X2_sky130_fd_sc_hd__fill_4
XFILLER_24_585 vssd1 vccd1 vccd1 vssd1 X2_sky130_fd_sc_hd__fill_2
XTAP_TAPCELL_ROW_34_591 vccd1 vssd1 X2_sky130_fd_sc_hd__tapvpwrvgnd_1
XFILLER_51_393 vssd1 vccd1 vccd1 vssd1 X2_sky130_fd_sc_hd__fill_4
XFILLER_7_217 vssd1 vccd1 vccd1 vssd1 X2_sky130_fd_sc_hd__fill_4
XFILLER_11_279 vccd1 vssd1 vccd1 vssd1 X2_sky130_fd_sc_hd__fill_1
Xclkload0 vccd1 vssd1 vssd1 vccd1 _553_/CLK clkload0/Y X2_sky130_fd_sc_hd__clkinv_1
XFILLER_50_77 vssd1 vccd1 vccd1 vssd1 X2_sky130_fd_sc_hd__fill_4
XFILLER_3_445 vssd1 vccd1 vccd1 vssd1 X2_sky130_fd_sc_hd__fill_2
XFILLER_66_419 vccd1 vssd1 vccd1 vssd1 X2_sky130_fd_sc_hd__fill_1
XTAP_TAPCELL_ROW_6_283 vccd1 vssd1 X2_sky130_fd_sc_hd__tapvpwrvgnd_1
XFILLER_93_205 vssd1 vccd1 vssd1 vccd1 X2_sky130_ef_sc_hd__decap_40_12
XFILLER_19_335 vccd1 vssd1 vccd1 vssd1 X2_sky130_fd_sc_hd__fill_1
XFILLER_93_249 vssd1 vccd1 vccd1 vssd1 X2_sky130_fd_sc_hd__fill_4
XFILLER_46_121 vssd1 vccd1 vssd1 vccd1 X2_sky130_ef_sc_hd__decap_40_12
XFILLER_46_165 vssd1 vccd1 vssd1 vccd1 X2_sky130_ef_sc_hd__decap_40_12
XFILLER_61_113 vssd1 vccd1 vssd1 vccd1 X2_sky130_ef_sc_hd__decap_40_12
XFILLER_15_541 vssd1 vccd1 vssd1 vccd1 X2_sky130_ef_sc_hd__decap_40_12
XFILLER_91_51 vssd1 vccd1 vccd1 vssd1 X2_sky130_fd_sc_hd__fill_4
XFILLER_15_585 vssd1 vccd1 vssd1 vccd1 X2_sky130_ef_sc_hd__decap_40_12
XFILLER_30_533 vssd1 vccd1 vssd1 vccd1 X2_sky130_ef_sc_hd__decap_40_12
X_308_ vccd1 vssd1 vccd1 vssd1 _304_/X _569_/Q _303_/X _308_/X hold13/X X2_sky130_fd_sc_hd__a22o_1
XFILLER_41_3 vssd1 vccd1 vssd1 vccd1 X2_sky130_ef_sc_hd__decap_40_12
XFILLER_69_279 vccd1 vssd1 vccd1 vssd1 X2_sky130_fd_sc_hd__fill_1
XFILLER_84_249 vssd1 vccd1 vccd1 vssd1 X2_sky130_fd_sc_hd__fill_2
XFILLER_65_441 vssd1 vccd1 vccd1 vssd1 X2_sky130_fd_sc_hd__fill_4
XFILLER_25_305 vssd1 vccd1 vssd1 vccd1 X2_sky130_ef_sc_hd__decap_40_12
XFILLER_37_165 vssd1 vccd1 vccd1 vssd1 X2_sky130_fd_sc_hd__fill_2
XFILLER_1_93 vssd1 vccd1 vssd1 vccd1 X2_sky130_ef_sc_hd__decap_40_12
XFILLER_25_349 vssd1 vccd1 vssd1 vccd1 X2_sky130_ef_sc_hd__decap_40_12
XFILLER_80_433 vssd1 vccd1 vssd1 vccd1 X2_sky130_ef_sc_hd__decap_40_12
XFILLER_80_477 vssd1 vccd1 vssd1 vccd1 X2_sky130_ef_sc_hd__decap_40_12
XFILLER_33_393 vccd1 vssd1 vccd1 vssd1 X2_sky130_fd_sc_hd__fill_1
XTAP_TAPCELL_ROW_31_561 vccd1 vssd1 X2_sky130_fd_sc_hd__tapvpwrvgnd_1
XFILLER_4_209 vssd1 vccd1 vssd1 vccd1 X2_sky130_ef_sc_hd__decap_40_12
XFILLER_88_533 vssd1 vccd1 vssd1 vccd1 X2_sky130_ef_sc_hd__decap_40_12
XFILLER_96_29 vssd1 vccd1 vssd1 vccd1 X2_sky130_ef_sc_hd__decap_40_12
Xhold12 _571_/D _306_/X vccd1 vssd1 vssd1 vccd1 X2_sky130_fd_sc_hd__dlygate4sd3_1
Xhold23 hold23/X _590_/Q vccd1 vssd1 vssd1 vccd1 X2_sky130_fd_sc_hd__dlygate4sd3_1
Xhold45 hold45/X _585_/Q vccd1 vssd1 vssd1 vccd1 X2_sky130_fd_sc_hd__dlygate4sd3_1
XFILLER_75_205 vssd1 vccd1 vssd1 vccd1 X2_sky130_ef_sc_hd__decap_40_12
Xhold34 hold34/X _564_/Q vccd1 vssd1 vssd1 vccd1 X2_sky130_fd_sc_hd__dlygate4sd3_1
Xhold56 _582_/D _441_/X vccd1 vssd1 vssd1 vccd1 X2_sky130_fd_sc_hd__dlygate4sd3_1
XTAP_TAPCELL_ROW_3_253 vccd1 vssd1 X2_sky130_fd_sc_hd__tapvpwrvgnd_1
XFILLER_28_121 vssd1 vccd1 vssd1 vccd1 X2_sky130_ef_sc_hd__decap_40_12
XFILLER_75_249 vssd1 vccd1 vssd1 vccd1 X2_sky130_ef_sc_hd__decap_40_12
Xhold89 hold3/A _544_/Q vccd1 vssd1 vssd1 vccd1 X2_sky130_fd_sc_hd__dlygate4sd3_1
Xhold67 hold67/X _597_/Q vccd1 vssd1 vssd1 vccd1 X2_sky130_fd_sc_hd__dlygate4sd3_1
Xhold78 hold78/X _575_/Q vccd1 vssd1 vssd1 vccd1 X2_sky130_fd_sc_hd__dlygate4sd3_1
XFILLER_16_305 vssd1 vccd1 vccd1 vssd1 X2_sky130_fd_sc_hd__fill_2
XFILLER_28_165 vssd1 vccd1 vssd1 vccd1 X2_sky130_ef_sc_hd__decap_40_12
XTAP_TAPCELL_ROW_39_650 vccd1 vssd1 X2_sky130_fd_sc_hd__tapvpwrvgnd_1
X_590_ vssd1 vccd1 vccd1 vssd1 _606_/CLK _590_/D _510_/Y _590_/Q X2_sky130_fd_sc_hd__dfrtp_1
XFILLER_83_293 vssd1 vccd1 vssd1 vccd1 X2_sky130_ef_sc_hd__decap_40_12
XFILLER_45_55 vccd1 vssd1 vccd1 vssd1 X2_sky130_fd_sc_hd__fill_1
XFILLER_43_113 vssd1 vccd1 vssd1 vccd1 X2_sky130_ef_sc_hd__decap_40_12
XFILLER_12_533 vssd1 vccd1 vssd1 vccd1 X2_sky130_ef_sc_hd__decap_40_12
XFILLER_101_83 vccd1 vssd1 vccd1 vssd1 X2_sky130_fd_sc_hd__fill_1
XTAP_TAPCELL_ROW_100_1317 vccd1 vssd1 X2_sky130_fd_sc_hd__tapvpwrvgnd_1
XANTENNA__263__A _473_/A vssd1 vccd1 vccd1 vssd1 X2_sky130_fd_sc_hd__diode_2
XFILLER_6_27 vccd1 vssd1 vccd1 vssd1 X2_sky130_fd_sc_hd__fill_1
Xclkbuf_3_2__f_wb_clk_i vssd1 vccd1 vssd1 vccd1 clkbuf_0_wb_clk_i/X _601_/CLK X2_sky130_fd_sc_hd__clkbuf_16
XFILLER_94_525 vssd1 vccd1 vccd1 vssd1 X2_sky130_fd_sc_hd__fill_4
XFILLER_94_569 vssd1 vccd1 vssd1 vccd1 X2_sky130_ef_sc_hd__decap_40_12
XFILLER_66_249 vssd1 vccd1 vccd1 vssd1 X2_sky130_fd_sc_hd__fill_2
XFILLER_19_165 vssd1 vccd1 vccd1 vssd1 X2_sky130_fd_sc_hd__fill_2
XFILLER_62_433 vssd1 vccd1 vssd1 vccd1 X2_sky130_ef_sc_hd__decap_40_12
XFILLER_62_477 vssd1 vccd1 vssd1 vccd1 X2_sky130_ef_sc_hd__decap_40_12
XFILLER_15_393 vssd1 vccd1 vssd1 vccd1 X2_sky130_ef_sc_hd__decap_40_12
XFILLER_30_330 vssd1 vccd1 vssd1 vccd1 X2_sky130_ef_sc_hd__decap_40_12
XFILLER_89_3 vssd1 vccd1 vssd1 vccd1 X2_sky130_ef_sc_hd__decap_40_12
XTAP_TAPCELL_ROW_77_1065 vccd1 vssd1 X2_sky130_fd_sc_hd__tapvpwrvgnd_1
XTAP_TAPCELL_ROW_90_1210 vccd1 vssd1 X2_sky130_fd_sc_hd__tapvpwrvgnd_1
XANTENNA__532__CLK _553_/CLK vssd1 vccd1 vccd1 vssd1 X2_sky130_fd_sc_hd__diode_2
XFILLER_85_503 vccd1 vssd1 vccd1 vssd1 X2_sky130_fd_sc_hd__fill_1
XFILLER_57_205 vssd1 vccd1 vssd1 vccd1 X2_sky130_ef_sc_hd__decap_40_12
XFILLER_57_249 vssd1 vccd1 vssd1 vccd1 X2_sky130_ef_sc_hd__decap_40_12
XTAP_TAPCELL_ROW_0_212 vccd1 vssd1 X2_sky130_fd_sc_hd__tapvpwrvgnd_1
XFILLER_38_463 vssd1 vccd1 vccd1 vssd1 X2_sky130_fd_sc_hd__fill_2
XTAP_TAPCELL_ROW_0_223 vccd1 vssd1 X2_sky130_fd_sc_hd__tapvpwrvgnd_1
XFILLER_25_113 vssd1 vccd1 vssd1 vccd1 X2_sky130_ef_sc_hd__decap_40_12
XTAP_TAPCELL_ROW_36_620 vccd1 vssd1 X2_sky130_fd_sc_hd__tapvpwrvgnd_1
XTAP_TAPCELL_ROW_88_1183 vccd1 vssd1 X2_sky130_fd_sc_hd__tapvpwrvgnd_1
XPHY_EDGE_ROW_69_Left_171 vccd1 vssd1 vccd1 vssd1 X2_sky130_fd_sc_hd__decap_3
XFILLER_41_617 vssd1 vccd1 vccd1 vssd1 X2_sky130_fd_sc_hd__fill_4
XFILLER_15_69 vssd1 vccd1 vssd1 vccd1 X2_sky130_ef_sc_hd__decap_40_12
XFILLER_21_385 vssd1 vccd1 vccd1 vssd1 X2_sky130_fd_sc_hd__fill_4
XFILLER_5_529 vssd1 vccd1 vssd1 vccd1 X2_sky130_ef_sc_hd__decap_40_12
XFILLER_31_57 vssd1 vccd1 vssd1 vccd1 X2_sky130_ef_sc_hd__decap_40_12
XPHY_EDGE_ROW_78_Left_180 vccd1 vssd1 vccd1 vssd1 X2_sky130_fd_sc_hd__decap_3
XTAP_TAPCELL_ROW_8_312 vccd1 vssd1 X2_sky130_fd_sc_hd__tapvpwrvgnd_1
XFILLER_0_212 vssd1 vccd1 vssd1 vccd1 X2_sky130_ef_sc_hd__decap_40_12
Xoutput57 vccd1 vssd1 wbs_dat_o[8] _565_/Q vccd1 vssd1 X2_sky130_fd_sc_hd__buf_2
Xoutput46 vccd1 vssd1 wbs_dat_o[12] _569_/Q vccd1 vssd1 X2_sky130_fd_sc_hd__buf_2
XFILLER_76_525 vssd1 vccd1 vccd1 vssd1 X2_sky130_fd_sc_hd__fill_4
XFILLER_48_205 vssd1 vccd1 vccd1 vssd1 X2_sky130_fd_sc_hd__fill_2
XFILLER_76_569 vssd1 vccd1 vssd1 vccd1 X2_sky130_ef_sc_hd__decap_40_12
XFILLER_48_249 vssd1 vccd1 vccd1 vssd1 X2_sky130_fd_sc_hd__fill_2
XFILLER_29_441 vssd1 vccd1 vccd1 vssd1 X2_sky130_fd_sc_hd__fill_4
XFILLER_91_517 vssd1 vccd1 vssd1 vccd1 X2_sky130_ef_sc_hd__decap_40_12
XFILLER_56_65 vssd1 vccd1 vssd1 vccd1 X2_sky130_ef_sc_hd__decap_40_12
XFILLER_29_485 vssd1 vccd1 vssd1 vccd1 X2_sky130_ef_sc_hd__decap_40_12
XFILLER_56_271 vccd1 vssd1 vccd1 vssd1 X2_sky130_fd_sc_hd__fill_1
XPHY_EDGE_ROW_19_Right_19 vccd1 vssd1 vccd1 vssd1 X2_sky130_fd_sc_hd__decap_3
X_573_ vssd1 vccd1 vccd1 vssd1 _606_/CLK _573_/D _493_/Y _573_/Q X2_sky130_fd_sc_hd__dfrtp_2
XFILLER_31_105 vssd1 vccd1 vccd1 vssd1 X2_sky130_fd_sc_hd__fill_4
XFILLER_72_53 vssd1 vccd1 vssd1 vccd1 X2_sky130_ef_sc_hd__decap_40_12
XFILLER_44_499 vssd1 vccd1 vccd1 vssd1 X2_sky130_fd_sc_hd__fill_4
XFILLER_44_477 vccd1 vssd1 vccd1 vssd1 X2_sky130_fd_sc_hd__fill_1
XFILLER_31_149 vssd1 vccd1 vssd1 vccd1 X2_sky130_ef_sc_hd__decap_40_12
XFILLER_8_301 vssd1 vccd1 vccd1 vssd1 X2_sky130_fd_sc_hd__fill_4
XFILLER_12_363 vccd1 vssd1 vccd1 vssd1 X2_sky130_fd_sc_hd__fill_1
XTAP_TAPCELL_ROW_14_369 vccd1 vssd1 X2_sky130_fd_sc_hd__tapvpwrvgnd_1
XFILLER_72_97 vssd1 vccd1 vssd1 vccd1 X2_sky130_ef_sc_hd__decap_40_12
XTAP_TAPCELL_ROW_70_987 vccd1 vssd1 X2_sky130_fd_sc_hd__tapvpwrvgnd_1
XTAP_TAPCELL_ROW_42_678 vccd1 vssd1 X2_sky130_fd_sc_hd__tapvpwrvgnd_1
XFILLER_8_345 vssd1 vccd1 vssd1 vccd1 X2_sky130_ef_sc_hd__decap_40_12
XFILLER_8_389 vssd1 vccd1 vssd1 vccd1 X2_sky130_ef_sc_hd__decap_40_12
XPHY_EDGE_ROW_28_Right_28 vccd1 vssd1 vccd1 vssd1 X2_sky130_fd_sc_hd__decap_3
XFILLER_99_617 vssd1 vccd1 vccd1 vssd1 X2_sky130_fd_sc_hd__fill_4
XANTENNA__555__CLK _599_/CLK vssd1 vccd1 vccd1 vssd1 X2_sky130_fd_sc_hd__diode_2
XFILLER_39_205 vssd1 vccd1 vssd1 vccd1 X2_sky130_ef_sc_hd__decap_40_12
XFILLER_94_300 vssd1 vccd1 vccd1 vssd1 X2_sky130_fd_sc_hd__fill_8
XFILLER_79_385 vssd1 vccd1 vccd1 vssd1 X2_sky130_fd_sc_hd__fill_4
XFILLER_67_503 vccd1 vssd1 vccd1 vssd1 X2_sky130_fd_sc_hd__fill_1
XFILLER_39_249 vssd1 vccd1 vssd1 vccd1 X2_sky130_ef_sc_hd__decap_40_12
XFILLER_94_333 vssd1 vccd1 vssd1 vccd1 X2_sky130_ef_sc_hd__decap_40_12
XFILLER_94_377 vssd1 vccd1 vssd1 vccd1 X2_sky130_ef_sc_hd__decap_40_12
XFILLER_54_208 vssd1 vccd1 vssd1 vccd1 X2_sky130_ef_sc_hd__decap_40_12
XPHY_EDGE_ROW_37_Right_37 vccd1 vssd1 vccd1 vssd1 X2_sky130_fd_sc_hd__decap_3
XFILLER_23_617 vssd1 vccd1 vccd1 vssd1 X2_sky130_fd_sc_hd__fill_8
XFILLER_50_447 vssd1 vccd1 vssd1 vccd1 X2_sky130_ef_sc_hd__decap_40_12
XFILLER_30_193 vssd1 vccd1 vccd1 vssd1 X2_sky130_fd_sc_hd__fill_2
XPHY_EDGE_ROW_46_Right_46 vccd1 vssd1 vccd1 vssd1 X2_sky130_fd_sc_hd__decap_3
XFILLER_7_81 vssd1 vccd1 vssd1 vccd1 X2_sky130_ef_sc_hd__decap_40_12
XFILLER_89_105 vssd1 vccd1 vccd1 vssd1 X2_sky130_fd_sc_hd__fill_4
XFILLER_89_149 vssd1 vccd1 vssd1 vccd1 X2_sky130_ef_sc_hd__decap_40_12
XFILLER_58_525 vssd1 vccd1 vccd1 vssd1 X2_sky130_fd_sc_hd__fill_4
XFILLER_97_193 vssd1 vccd1 vssd1 vccd1 X2_sky130_ef_sc_hd__decap_40_12
XFILLER_73_517 vssd1 vccd1 vssd1 vccd1 X2_sky130_ef_sc_hd__decap_40_12
XFILLER_58_569 vssd1 vccd1 vccd1 vssd1 X2_sky130_fd_sc_hd__fill_4
XPHY_EDGE_ROW_55_Right_55 vccd1 vssd1 vccd1 vssd1 X2_sky130_fd_sc_hd__decap_3
XFILLER_26_433 vssd1 vccd1 vssd1 vccd1 X2_sky130_ef_sc_hd__decap_40_12
XFILLER_13_105 vssd1 vccd1 vccd1 vssd1 X2_sky130_fd_sc_hd__fill_4
XFILLER_26_477 vssd1 vccd1 vssd1 vccd1 X2_sky130_ef_sc_hd__decap_40_12
XFILLER_81_561 vssd1 vccd1 vssd1 vccd1 X2_sky130_ef_sc_hd__decap_40_12
XFILLER_13_149 vssd1 vccd1 vssd1 vccd1 X2_sky130_ef_sc_hd__decap_40_12
XFILLER_41_447 vccd1 vssd1 vccd1 vssd1 X2_sky130_fd_sc_hd__fill_1
XFILLER_41_436 vssd1 vccd1 vccd1 vssd1 X2_sky130_fd_sc_hd__fill_2
XFILLER_41_425 vccd1 vssd1 vccd1 vssd1 X2_sky130_fd_sc_hd__fill_1
XFILLER_9_109 vssd1 vccd1 vccd1 vssd1 X2_sky130_fd_sc_hd__fill_2
XFILLER_42_23 vssd1 vccd1 vccd1 vssd1 X2_sky130_fd_sc_hd__fill_4
XPHY_EDGE_ROW_64_Right_64 vccd1 vssd1 vccd1 vssd1 X2_sky130_fd_sc_hd__decap_3
XTAP_TAPCELL_ROW_11_339 vccd1 vssd1 X2_sky130_fd_sc_hd__tapvpwrvgnd_1
XFILLER_21_193 vssd1 vccd1 vssd1 vccd1 X2_sky130_ef_sc_hd__decap_40_12
XFILLER_5_337 vssd1 vccd1 vssd1 vccd1 X2_sky130_ef_sc_hd__decap_40_12
XFILLER_3_39 vssd1 vccd1 vssd1 vccd1 X2_sky130_ef_sc_hd__decap_40_12
XFILLER_88_193 vssd1 vccd1 vccd1 vssd1 X2_sky130_fd_sc_hd__fill_2
XFILLER_76_333 vssd1 vccd1 vssd1 vccd1 X2_sky130_ef_sc_hd__decap_40_12
XPHY_EDGE_ROW_73_Right_73 vccd1 vssd1 vccd1 vssd1 X2_sky130_fd_sc_hd__decap_3
XFILLER_76_377 vssd1 vccd1 vssd1 vccd1 X2_sky130_ef_sc_hd__decap_40_12
XTAP_TAPCELL_ROW_19_428 vccd1 vssd1 X2_sky130_fd_sc_hd__tapvpwrvgnd_1
XFILLER_29_271 vccd1 vssd1 vccd1 vssd1 X2_sky130_fd_sc_hd__fill_1
XTAP_TAPCELL_ROW_47_737 vccd1 vssd1 X2_sky130_fd_sc_hd__tapvpwrvgnd_1
X_556_ vssd1 vccd1 vccd1 vssd1 _601_/CLK _556_/D _476_/Y _556_/Q X2_sky130_fd_sc_hd__dfrtp_1
XFILLER_32_436 vssd1 vccd1 vccd1 vssd1 X2_sky130_fd_sc_hd__fill_2
X_487_ vccd1 vssd1 vccd1 vssd1 _487_/Y _521_/A X2_sky130_fd_sc_hd__inv_2
XPHY_EDGE_ROW_82_Right_82 vccd1 vssd1 vccd1 vssd1 X2_sky130_fd_sc_hd__decap_3
XFILLER_8_153 vssd1 vccd1 vssd1 vccd1 X2_sky130_ef_sc_hd__decap_40_12
XFILLER_12_193 vssd1 vccd1 vccd1 vssd1 X2_sky130_fd_sc_hd__fill_2
XFILLER_8_197 vssd1 vccd1 vssd1 vccd1 X2_sky130_ef_sc_hd__decap_40_12
XANTENNA__451__A _473_/A vssd1 vccd1 vccd1 vssd1 X2_sky130_fd_sc_hd__diode_2
XFILLER_99_414 vssd1 vccd1 vccd1 vssd1 X2_sky130_fd_sc_hd__fill_2
XTAP_TAPCELL_ROW_74_1035 vccd1 vssd1 X2_sky130_fd_sc_hd__tapvpwrvgnd_1
XFILLER_87_609 vssd1 vccd1 vccd1 vssd1 X2_sky130_fd_sc_hd__fill_4
XFILLER_99_447 vccd1 vssd1 vccd1 vssd1 X2_sky130_fd_sc_hd__fill_1
XPHY_EDGE_ROW_91_Right_91 vccd1 vssd1 vccd1 vssd1 X2_sky130_fd_sc_hd__decap_3
XFILLER_101_419 vccd1 vssd1 vccd1 vssd1 X2_sky130_fd_sc_hd__fill_1
XFILLER_79_193 vssd1 vccd1 vssd1 vccd1 X2_sky130_ef_sc_hd__decap_40_12
XFILLER_94_141 vssd1 vccd1 vssd1 vccd1 X2_sky130_ef_sc_hd__decap_40_12
XFILLER_55_517 vssd1 vccd1 vssd1 vccd1 X2_sky130_ef_sc_hd__decap_40_12
XTAP_TAPCELL_ROW_85_1153 vccd1 vssd1 X2_sky130_fd_sc_hd__tapvpwrvgnd_1
XFILLER_63_561 vssd1 vccd1 vssd1 vccd1 X2_sky130_ef_sc_hd__decap_40_12
XFILLER_23_447 vccd1 vssd1 vccd1 vssd1 X2_sky130_fd_sc_hd__fill_1
XFILLER_11_609 vssd1 vccd1 vccd1 vssd1 X2_sky130_fd_sc_hd__fill_4
XFILLER_50_277 vssd1 vccd1 vccd1 vssd1 X2_sky130_fd_sc_hd__fill_2
XFILLER_12_15 vssd1 vccd1 vssd1 vccd1 X2_sky130_ef_sc_hd__decap_40_12
XFILLER_2_307 vccd1 vssd1 vccd1 vssd1 X2_sky130_fd_sc_hd__fill_1
XTAP_TAPCELL_ROW_96_1271 vccd1 vssd1 X2_sky130_fd_sc_hd__tapvpwrvgnd_1
XFILLER_58_377 vssd1 vccd1 vssd1 vccd1 X2_sky130_ef_sc_hd__decap_40_12
XFILLER_46_517 vssd1 vccd1 vssd1 vccd1 X2_sky130_ef_sc_hd__decap_40_12
X_410_ vccd1 vssd1 vccd1 vssd1 _377_/B _393_/C _362_/X _411_/B X2_sky130_fd_sc_hd__a21oi_1
XTAP_TAPCELL_ROW_44_707 vccd1 vssd1 X2_sky130_fd_sc_hd__tapvpwrvgnd_1
XFILLER_41_222 vssd1 vccd1 vccd1 vssd1 X2_sky130_fd_sc_hd__fill_2
XFILLER_41_233 vssd1 vccd1 vccd1 vssd1 X2_sky130_fd_sc_hd__fill_2
XFILLER_81_391 vccd1 vssd1 vccd1 vssd1 X2_sky130_fd_sc_hd__fill_1
X_341_ vssd1 vccd1 _341_/C _320_/B _341_/X _573_/Q _341_/B vccd1 vssd1 X2_sky130_fd_sc_hd__and4b_1
XFILLER_14_469 vssd1 vccd1 vccd1 vssd1 X2_sky130_fd_sc_hd__fill_4
XFILLER_53_55 vccd1 vssd1 vccd1 vssd1 X2_sky130_fd_sc_hd__fill_1
XTAP_TAPCELL_ROW_24_486 vccd1 vssd1 X2_sky130_fd_sc_hd__tapvpwrvgnd_1
XFILLER_41_277 vssd1 vccd1 vccd1 vssd1 X2_sky130_fd_sc_hd__fill_2
X_272_ vssd1 vccd1 vssd1 vccd1 _291_/A _289_/S _304_/A X2_sky130_fd_sc_hd__nand2_8
XTAP_TAPCELL_ROW_52_795 vccd1 vssd1 X2_sky130_fd_sc_hd__tapvpwrvgnd_1
XFILLER_6_613 vssd1 vccd1 vssd1 vccd1 X2_sky130_ef_sc_hd__decap_40_12
XFILLER_5_167 vccd1 vssd1 vccd1 vssd1 X2_sky130_fd_sc_hd__fill_1
XFILLER_78_41 vssd1 vccd1 vssd1 vccd1 X2_sky130_ef_sc_hd__decap_40_12
XFILLER_1_340 vssd1 vccd1 vccd1 vssd1 X2_sky130_fd_sc_hd__fill_2
XFILLER_96_406 vssd1 vccd1 vccd1 vssd1 X2_sky130_fd_sc_hd__fill_2
XFILLER_78_85 vssd1 vccd1 vssd1 vccd1 X2_sky130_ef_sc_hd__decap_40_12
XANTENNA_input31_X _297_/A0 vssd1 vccd1 vccd1 vssd1 X2_sky130_fd_sc_hd__diode_2
XFILLER_49_333 vssd1 vccd1 vccd1 vssd1 X2_sky130_fd_sc_hd__fill_2
XFILLER_92_601 vssd1 vccd1 vssd1 vccd1 X2_sky130_ef_sc_hd__decap_40_12
XFILLER_76_141 vssd1 vccd1 vssd1 vccd1 X2_sky130_ef_sc_hd__decap_40_12
XFILLER_49_355 vssd1 vccd1 vccd1 vssd1 X2_sky130_fd_sc_hd__fill_4
XFILLER_91_111 vccd1 vssd1 vccd1 vssd1 X2_sky130_fd_sc_hd__fill_1
XFILLER_64_303 vssd1 vccd1 vccd1 vssd1 X2_sky130_fd_sc_hd__fill_2
XFILLER_64_347 vssd1 vccd1 vccd1 vssd1 X2_sky130_fd_sc_hd__fill_2
XFILLER_64_336 vssd1 vccd1 vccd1 vssd1 X2_sky130_fd_sc_hd__fill_8
X_608_ vssd1 vccd1 vccd1 vssd1 _608_/CLK hold1/X _528_/Y _608_/Q X2_sky130_fd_sc_hd__dfrtp_1
XFILLER_45_561 vssd1 vccd1 vssd1 vccd1 X2_sky130_ef_sc_hd__decap_40_12
XFILLER_32_211 vccd1 vssd1 vccd1 vssd1 X2_sky130_fd_sc_hd__fill_1
XFILLER_60_531 vccd1 vssd1 vccd1 vssd1 X2_sky130_fd_sc_hd__fill_1
X_539_ vssd1 vccd1 vccd1 vssd1 _601_/CLK _539_/D _459_/Y _539_/Q X2_sky130_fd_sc_hd__dfrtp_4
XFILLER_20_417 vssd1 vccd1 vccd1 vssd1 X2_sky130_fd_sc_hd__fill_2
XFILLER_32_277 vssd1 vccd1 vssd1 vccd1 X2_sky130_ef_sc_hd__decap_40_12
XFILLER_60_597 vccd1 vssd1 vccd1 vssd1 X2_sky130_fd_sc_hd__fill_1
XFILLER_9_473 vssd1 vccd1 vssd1 vccd1 X2_sky130_ef_sc_hd__decap_40_12
XFILLER_71_3 vssd1 vccd1 vssd1 vccd1 X2_sky130_ef_sc_hd__decap_40_12
XANTENNA_clkbuf_3_2__f_wb_clk_i_A clkbuf_0_wb_clk_i/X vssd1 vccd1 vccd1 vssd1 X2_sky130_fd_sc_hd__diode_2
XFILLER_87_417 vssd1 vccd1 vssd1 vccd1 X2_sky130_ef_sc_hd__decap_40_12
XFILLER_68_620 vssd1 vccd1 vccd1 vssd1 X2_sky130_fd_sc_hd__fill_2
XFILLER_101_249 vssd1 vccd1 vccd1 vssd1 X2_sky130_fd_sc_hd__fill_2
XFILLER_95_461 vssd1 vccd1 vssd1 vccd1 X2_sky130_ef_sc_hd__decap_40_12
XFILLER_82_133 vssd1 vccd1 vccd1 vssd1 X2_sky130_fd_sc_hd__fill_4
XFILLER_36_572 vssd1 vccd1 vccd1 vssd1 X2_sky130_fd_sc_hd__fill_2
XFILLER_82_177 vssd1 vccd1 vssd1 vccd1 X2_sky130_ef_sc_hd__decap_40_12
XFILLER_63_391 vccd1 vssd1 vccd1 vssd1 X2_sky130_fd_sc_hd__fill_1
XFILLER_51_553 vssd1 vccd1 vccd1 vssd1 X2_sky130_fd_sc_hd__fill_4
XFILLER_11_417 vssd1 vccd1 vssd1 vccd1 X2_sky130_ef_sc_hd__decap_40_12
XFILLER_23_277 vssd1 vccd1 vccd1 vssd1 X2_sky130_fd_sc_hd__fill_2
XFILLER_23_69 vssd1 vccd1 vssd1 vccd1 X2_sky130_ef_sc_hd__decap_40_12
XTAP_TAPCELL_ROW_98_1300 vccd1 vssd1 X2_sky130_fd_sc_hd__tapvpwrvgnd_1
XTAP_TAPCELL_ROW_21_456 vccd1 vssd1 X2_sky130_fd_sc_hd__tapvpwrvgnd_1
XFILLER_2_137 vssd1 vccd1 vccd1 vssd1 X2_sky130_fd_sc_hd__fill_2
XFILLER_78_417 vssd1 vccd1 vccd1 vssd1 X2_sky130_fd_sc_hd__fill_2
XFILLER_58_141 vssd1 vccd1 vssd1 vccd1 X2_sky130_ef_sc_hd__decap_40_12
XFILLER_19_517 vssd1 vccd1 vssd1 vccd1 X2_sky130_ef_sc_hd__decap_40_12
XFILLER_48_77 vssd1 vccd1 vccd1 vssd1 X2_sky130_fd_sc_hd__fill_4
XFILLER_0_29 vssd1 vccd1 vssd1 vccd1 X2_sky130_ef_sc_hd__decap_40_12
XTAP_TAPCELL_ROW_29_534 vccd1 vssd1 X2_sky130_fd_sc_hd__tapvpwrvgnd_1
XFILLER_73_111 vccd1 vssd1 vccd1 vssd1 X2_sky130_fd_sc_hd__fill_1
XTAP_TAPCELL_ROW_57_843 vccd1 vssd1 X2_sky130_fd_sc_hd__tapvpwrvgnd_1
XFILLER_27_561 vssd1 vccd1 vssd1 vccd1 X2_sky130_ef_sc_hd__decap_40_12
XFILLER_34_509 vssd1 vccd1 vccd1 vssd1 X2_sky130_fd_sc_hd__fill_2
XFILLER_61_317 vssd1 vccd1 vccd1 vssd1 X2_sky130_fd_sc_hd__fill_2
XFILLER_46_369 vssd1 vccd1 vssd1 vccd1 X2_sky130_ef_sc_hd__decap_40_12
XPHY_EDGE_ROW_14_Left_116 vccd1 vssd1 vccd1 vssd1 X2_sky130_fd_sc_hd__decap_3
XFILLER_64_65 vssd1 vccd1 vssd1 vccd1 X2_sky130_ef_sc_hd__decap_40_12
XFILLER_42_520 vssd1 vccd1 vssd1 vccd1 X2_sky130_ef_sc_hd__decap_40_12
XFILLER_9_27 vssd1 vccd1 vssd1 vccd1 X2_sky130_ef_sc_hd__decap_40_12
XFILLER_14_233 vssd1 vccd1 vssd1 vccd1 X2_sky130_ef_sc_hd__decap_40_12
XFILLER_42_542 vssd1 vccd1 vccd1 vssd1 X2_sky130_fd_sc_hd__fill_2
XFILLER_14_277 vssd1 vccd1 vssd1 vccd1 X2_sky130_ef_sc_hd__decap_40_12
X_324_ vccd1 vssd1 vccd1 vssd1 _580_/Q _291_/B _324_/X _317_/C _551_/D _303_/X X2_sky130_fd_sc_hd__a221o_1
XFILLER_42_586 vssd1 vccd1 vccd1 vssd1 X2_sky130_fd_sc_hd__fill_2
XFILLER_80_53 vssd1 vccd1 vssd1 vccd1 X2_sky130_ef_sc_hd__decap_40_12
XFILLER_80_97 vssd1 vccd1 vssd1 vccd1 X2_sky130_ef_sc_hd__decap_40_12
XANTENNA__272__Y _289_/S vssd1 vccd1 vccd1 vssd1 X2_sky130_fd_sc_hd__diode_2
XFILLER_6_421 vssd1 vccd1 vssd1 vccd1 X2_sky130_ef_sc_hd__decap_40_12
XPHY_EDGE_ROW_23_Left_125 vccd1 vssd1 vccd1 vssd1 X2_sky130_fd_sc_hd__decap_3
XFILLER_89_51 vssd1 vccd1 vccd1 vssd1 X2_sky130_fd_sc_hd__fill_4
XTAP_TAPCELL_ROW_71_1005 vccd1 vssd1 X2_sky130_fd_sc_hd__tapvpwrvgnd_1
XFILLER_69_417 vssd1 vccd1 vssd1 vccd1 X2_sky130_ef_sc_hd__decap_40_12
XFILLER_1_181 vssd1 vccd1 vssd1 vccd1 X2_sky130_ef_sc_hd__decap_40_12
XFILLER_77_461 vssd1 vccd1 vssd1 vccd1 X2_sky130_ef_sc_hd__decap_40_12
XFILLER_37_358 vssd1 vccd1 vccd1 vssd1 X2_sky130_fd_sc_hd__fill_4
XFILLER_64_133 vssd1 vccd1 vccd1 vssd1 X2_sky130_fd_sc_hd__fill_4
XPHY_EDGE_ROW_32_Left_134 vccd1 vssd1 vccd1 vssd1 X2_sky130_fd_sc_hd__decap_3
XFILLER_92_475 vccd1 vssd1 vccd1 vssd1 X2_sky130_fd_sc_hd__fill_1
XFILLER_64_177 vssd1 vccd1 vssd1 vccd1 X2_sky130_ef_sc_hd__decap_40_12
XFILLER_52_317 vssd1 vccd1 vccd1 vssd1 X2_sky130_fd_sc_hd__fill_2
XFILLER_52_306 vssd1 vccd1 vccd1 vssd1 X2_sky130_fd_sc_hd__fill_2
XTAP_TAPCELL_ROW_82_1123 vccd1 vssd1 X2_sky130_fd_sc_hd__tapvpwrvgnd_1
XFILLER_33_564 vssd1 vccd1 vssd1 vccd1 X2_sky130_ef_sc_hd__decap_40_12
XFILLER_60_350 vssd1 vccd1 vssd1 vccd1 X2_sky130_ef_sc_hd__decap_40_12
XFILLER_45_391 vccd1 vssd1 vccd1 vssd1 X2_sky130_fd_sc_hd__fill_1
XFILLER_9_281 vssd1 vccd1 vssd1 vccd1 X2_sky130_ef_sc_hd__decap_40_12
XPHY_EDGE_ROW_41_Left_143 vccd1 vssd1 vccd1 vssd1 X2_sky130_fd_sc_hd__decap_3
XTAP_TAPCELL_ROW_93_1241 vccd1 vssd1 X2_sky130_fd_sc_hd__tapvpwrvgnd_1
XFILLER_87_225 vssd1 vccd1 vssd1 vccd1 X2_sky130_ef_sc_hd__decap_40_12
XPHY_EDGE_ROW_50_Left_152 vccd1 vssd1 vccd1 vssd1 X2_sky130_fd_sc_hd__decap_3
XFILLER_55_111 vccd1 vssd1 vccd1 vssd1 X2_sky130_fd_sc_hd__fill_1
XTAP_TAPCELL_ROW_26_504 vccd1 vssd1 X2_sky130_fd_sc_hd__tapvpwrvgnd_1
XFILLER_71_615 vccd1 vssd1 vccd1 vssd1 X2_sky130_fd_sc_hd__fill_1
XTAP_TAPCELL_ROW_54_813 vccd1 vssd1 X2_sky130_fd_sc_hd__tapvpwrvgnd_1
XFILLER_83_497 vssd1 vccd1 vccd1 vssd1 X2_sky130_fd_sc_hd__fill_4
XFILLER_24_531 vccd1 vssd1 vccd1 vssd1 X2_sky130_fd_sc_hd__fill_1
XFILLER_51_361 vssd1 vccd1 vssd1 vccd1 X2_sky130_ef_sc_hd__decap_40_12
XFILLER_11_225 vssd1 vccd1 vssd1 vccd1 X2_sky130_ef_sc_hd__decap_40_12
XTAP_TAPCELL_ROW_34_592 vccd1 vssd1 X2_sky130_fd_sc_hd__tapvpwrvgnd_1
Xclkload1 vssd1 vccd1 vccd1 vssd1 _608_/CLK clkload1/Y X2_sky130_fd_sc_hd__clkinv_2
XFILLER_1_3 vssd1 vccd1 vssd1 vccd1 X2_sky130_ef_sc_hd__decap_40_12
Xclkbuf_3_1__f_wb_clk_i vssd1 vccd1 vssd1 vccd1 clkbuf_0_wb_clk_i/X _608_/CLK X2_sky130_fd_sc_hd__clkbuf_16
XANTENNA_input39_A wbs_stb_i vssd1 vccd1 vccd1 vssd1 X2_sky130_fd_sc_hd__diode_2
XTAP_TAPCELL_ROW_6_284 vccd1 vssd1 X2_sky130_fd_sc_hd__tapvpwrvgnd_1
XFILLER_93_217 vssd1 vccd1 vccd1 vssd1 X2_sky130_fd_sc_hd__fill_4
XFILLER_59_461 vssd1 vccd1 vssd1 vccd1 X2_sky130_ef_sc_hd__decap_40_12
XFILLER_47_612 vssd1 vccd1 vccd1 vssd1 X2_sky130_fd_sc_hd__fill_4
XFILLER_46_133 vssd1 vccd1 vccd1 vssd1 X2_sky130_fd_sc_hd__fill_4
XFILLER_74_475 vccd1 vssd1 vccd1 vssd1 X2_sky130_fd_sc_hd__fill_1
XFILLER_61_125 vssd1 vccd1 vssd1 vccd1 X2_sky130_ef_sc_hd__decap_40_12
XFILLER_46_177 vccd1 vssd1 vccd1 vssd1 X2_sky130_fd_sc_hd__fill_1
XFILLER_15_553 vssd1 vccd1 vccd1 vssd1 X2_sky130_fd_sc_hd__fill_4
XFILLER_27_391 vccd1 vssd1 vccd1 vssd1 X2_sky130_fd_sc_hd__fill_1
XFILLER_61_169 vssd1 vccd1 vssd1 vccd1 X2_sky130_ef_sc_hd__decap_40_12
XFILLER_15_597 vssd1 vccd1 vssd1 vccd1 X2_sky130_ef_sc_hd__decap_40_12
XFILLER_30_501 vssd1 vccd1 vssd1 vccd1 X2_sky130_ef_sc_hd__decap_40_12
XFILLER_42_350 vssd1 vccd1 vccd1 vssd1 X2_sky130_fd_sc_hd__fill_2
XFILLER_30_545 vssd1 vccd1 vssd1 vccd1 X2_sky130_ef_sc_hd__decap_40_12
X_307_ vccd1 vssd1 vccd1 vssd1 _304_/X _570_/Q _303_/X hold8/A hold7/X X2_sky130_fd_sc_hd__a22o_1
XFILLER_30_589 vssd1 vccd1 vssd1 vccd1 X2_sky130_ef_sc_hd__decap_40_12
XFILLER_6_251 vccd1 vssd1 vccd1 vssd1 X2_sky130_fd_sc_hd__fill_1
XANTENNA__298__A0 _298_/A0 vssd1 vccd1 vccd1 vssd1 X2_sky130_fd_sc_hd__diode_2
XFILLER_97_501 vssd1 vccd1 vccd1 vssd1 X2_sky130_fd_sc_hd__fill_2
XFILLER_34_3 vssd1 vccd1 vssd1 vccd1 X2_sky130_ef_sc_hd__decap_40_12
XFILLER_69_225 vssd1 vccd1 vssd1 vccd1 X2_sky130_ef_sc_hd__decap_40_12
XFILLER_37_111 vccd1 vssd1 vccd1 vssd1 X2_sky130_fd_sc_hd__fill_1
XFILLER_80_401 vssd1 vccd1 vssd1 vccd1 X2_sky130_ef_sc_hd__decap_40_12
XFILLER_65_475 vccd1 vssd1 vccd1 vssd1 X2_sky130_fd_sc_hd__fill_1
XFILLER_53_615 vccd1 vssd1 vccd1 vssd1 X2_sky130_fd_sc_hd__fill_1
XFILLER_25_317 vssd1 vccd1 vssd1 vccd1 X2_sky130_ef_sc_hd__decap_40_12
XFILLER_37_177 vccd1 vssd1 vccd1 vssd1 X2_sky130_fd_sc_hd__fill_1
XFILLER_80_445 vssd1 vccd1 vssd1 vccd1 X2_sky130_ef_sc_hd__decap_40_12
XFILLER_21_501 vssd1 vccd1 vccd1 vssd1 X2_sky130_fd_sc_hd__fill_2
XFILLER_33_361 vssd1 vccd1 vccd1 vssd1 X2_sky130_fd_sc_hd__fill_8
XFILLER_40_309 vssd1 vccd1 vccd1 vssd1 X2_sky130_fd_sc_hd__fill_2
XFILLER_80_489 vssd1 vccd1 vssd1 vccd1 X2_sky130_ef_sc_hd__decap_40_12
XTAP_TAPCELL_ROW_31_562 vccd1 vssd1 X2_sky130_fd_sc_hd__tapvpwrvgnd_1
XFILLER_20_15 vssd1 vccd1 vssd1 vccd1 X2_sky130_ef_sc_hd__decap_40_12
XFILLER_88_501 vssd1 vccd1 vssd1 vccd1 X2_sky130_ef_sc_hd__decap_40_12
XFILLER_0_449 vssd1 vccd1 vccd1 vssd1 X2_sky130_fd_sc_hd__fill_8
XFILLER_88_545 vssd1 vccd1 vssd1 vccd1 X2_sky130_ef_sc_hd__decap_40_12
Xhold13 hold13/X _602_/Q vccd1 vssd1 vssd1 vccd1 X2_sky130_fd_sc_hd__dlygate4sd3_1
XFILLER_29_57 vssd1 vccd1 vssd1 vccd1 X2_sky130_ef_sc_hd__decap_40_12
Xhold24 hold24/X _593_/Q vccd1 vssd1 vssd1 vccd1 X2_sky130_fd_sc_hd__dlygate4sd3_1
XFILLER_88_589 vssd1 vccd1 vssd1 vccd1 X2_sky130_ef_sc_hd__decap_40_12
XFILLER_75_217 vssd1 vccd1 vccd1 vssd1 X2_sky130_fd_sc_hd__fill_4
Xhold35 _564_/D _322_/X vccd1 vssd1 vssd1 vccd1 X2_sky130_fd_sc_hd__dlygate4sd3_1
Xhold46 _551_/D _536_/Q vccd1 vssd1 vssd1 vccd1 X2_sky130_fd_sc_hd__dlygate4sd3_1
Xhold68 hold68/X _578_/Q vccd1 vssd1 vssd1 vccd1 X2_sky130_fd_sc_hd__dlygate4sd3_1
Xhold79 _348_/B _556_/Q vccd1 vssd1 vssd1 vccd1 X2_sky130_fd_sc_hd__dlygate4sd3_1
Xhold57 hold57/X _559_/Q vccd1 vssd1 vssd1 vccd1 X2_sky130_fd_sc_hd__dlygate4sd3_1
XTAP_TAPCELL_ROW_3_254 vccd1 vssd1 X2_sky130_fd_sc_hd__tapvpwrvgnd_1
XFILLER_28_133 vssd1 vccd1 vccd1 vssd1 X2_sky130_fd_sc_hd__fill_4
XTAP_TAPCELL_ROW_39_651 vccd1 vssd1 X2_sky130_fd_sc_hd__tapvpwrvgnd_1
XFILLER_90_209 vssd1 vccd1 vssd1 vccd1 X2_sky130_ef_sc_hd__decap_40_12
XTAP_TAPCELL_ROW_67_960 vccd1 vssd1 X2_sky130_fd_sc_hd__tapvpwrvgnd_1
XFILLER_56_475 vccd1 vssd1 vccd1 vssd1 X2_sky130_fd_sc_hd__fill_1
XFILLER_28_177 vssd1 vccd1 vssd1 vccd1 X2_sky130_ef_sc_hd__decap_40_12
XFILLER_83_261 vssd1 vccd1 vssd1 vccd1 X2_sky130_ef_sc_hd__decap_40_12
XFILLER_43_125 vssd1 vccd1 vssd1 vccd1 X2_sky130_ef_sc_hd__decap_40_12
XFILLER_71_445 vssd1 vccd1 vccd1 vssd1 X2_sky130_fd_sc_hd__fill_2
XFILLER_12_501 vssd1 vccd1 vssd1 vccd1 X2_sky130_ef_sc_hd__decap_40_12
XFILLER_24_361 vssd1 vccd1 vccd1 vssd1 X2_sky130_fd_sc_hd__fill_2
XFILLER_31_309 vssd1 vccd1 vssd1 vccd1 X2_sky130_ef_sc_hd__decap_40_12
XFILLER_43_169 vssd1 vccd1 vssd1 vccd1 X2_sky130_ef_sc_hd__decap_40_12
XFILLER_12_545 vssd1 vccd1 vssd1 vccd1 X2_sky130_ef_sc_hd__decap_40_12
XTAP_TAPCELL_ROW_100_1318 vccd1 vssd1 X2_sky130_fd_sc_hd__tapvpwrvgnd_1
XFILLER_12_589 vssd1 vccd1 vssd1 vccd1 X2_sky130_ef_sc_hd__decap_40_12
XFILLER_61_55 vccd1 vssd1 vccd1 vssd1 X2_sky130_fd_sc_hd__fill_1
XFILLER_3_221 vssd1 vccd1 vccd1 vssd1 X2_sky130_fd_sc_hd__fill_2
XFILLER_98_309 vccd1 vssd1 vccd1 vssd1 X2_sky130_fd_sc_hd__fill_1
XFILLER_79_501 vssd1 vccd1 vccd1 vssd1 X2_sky130_fd_sc_hd__fill_2
XFILLER_10_81 vssd1 vccd1 vccd1 vssd1 X2_sky130_fd_sc_hd__fill_2
XFILLER_86_41 vssd1 vccd1 vssd1 vccd1 X2_sky130_ef_sc_hd__decap_40_12
XFILLER_19_111 vccd1 vssd1 vccd1 vssd1 X2_sky130_fd_sc_hd__fill_1
XFILLER_86_85 vssd1 vccd1 vssd1 vccd1 X2_sky130_ef_sc_hd__decap_40_12
XFILLER_47_464 vssd1 vccd1 vccd1 vssd1 X2_sky130_fd_sc_hd__fill_2
XFILLER_35_615 vccd1 vssd1 vccd1 vssd1 X2_sky130_fd_sc_hd__fill_1
XFILLER_62_401 vssd1 vccd1 vssd1 vccd1 X2_sky130_ef_sc_hd__decap_40_12
XFILLER_62_445 vssd1 vccd1 vssd1 vccd1 X2_sky130_ef_sc_hd__decap_40_12
XFILLER_15_361 vssd1 vccd1 vssd1 vccd1 X2_sky130_ef_sc_hd__decap_40_12
XFILLER_22_309 vssd1 vccd1 vssd1 vccd1 X2_sky130_ef_sc_hd__decap_40_12
XFILLER_62_489 vssd1 vccd1 vssd1 vccd1 X2_sky130_ef_sc_hd__decap_40_12
XFILLER_30_342 vssd1 vccd1 vssd1 vccd1 X2_sky130_ef_sc_hd__decap_40_12
XANTENNA__454__A _473_/A vssd1 vccd1 vccd1 vssd1 X2_sky130_fd_sc_hd__diode_2
XFILLER_89_309 vssd1 vccd1 vccd1 vssd1 X2_sky130_fd_sc_hd__fill_8
XTAP_TAPCELL_ROW_77_1066 vccd1 vssd1 X2_sky130_fd_sc_hd__tapvpwrvgnd_1
XTAP_TAPCELL_ROW_90_1211 vccd1 vssd1 X2_sky130_fd_sc_hd__tapvpwrvgnd_1
XFILLER_97_320 vssd1 vccd1 vssd1 vccd1 X2_sky130_ef_sc_hd__decap_40_12
XFILLER_57_217 vssd1 vccd1 vccd1 vssd1 X2_sky130_fd_sc_hd__fill_4
XFILLER_85_559 vccd1 vssd1 vccd1 vssd1 X2_sky130_fd_sc_hd__fill_1
XFILLER_38_453 vssd1 vccd1 vccd1 vssd1 X2_sky130_fd_sc_hd__fill_2
XFILLER_72_209 vssd1 vccd1 vssd1 vccd1 X2_sky130_ef_sc_hd__decap_40_12
XTAP_TAPCELL_ROW_0_213 vccd1 vssd1 X2_sky130_fd_sc_hd__tapvpwrvgnd_1
XTAP_TAPCELL_ROW_0_224 vccd1 vssd1 X2_sky130_fd_sc_hd__tapvpwrvgnd_1
XFILLER_38_475 vccd1 vssd1 vccd1 vssd1 X2_sky130_fd_sc_hd__fill_1
XTAP_TAPCELL_ROW_88_1184 vccd1 vssd1 X2_sky130_fd_sc_hd__tapvpwrvgnd_1
XFILLER_25_125 vssd1 vccd1 vssd1 vccd1 X2_sky130_ef_sc_hd__decap_40_12
XTAP_TAPCELL_ROW_36_621 vccd1 vssd1 X2_sky130_fd_sc_hd__tapvpwrvgnd_1
XFILLER_15_15 vssd1 vccd1 vssd1 vccd1 X2_sky130_ef_sc_hd__decap_40_12
XFILLER_25_169 vssd1 vccd1 vssd1 vccd1 X2_sky130_ef_sc_hd__decap_40_12
XFILLER_80_253 vssd1 vccd1 vssd1 vccd1 X2_sky130_ef_sc_hd__decap_40_12
XFILLER_40_139 vccd1 vssd1 vccd1 vssd1 X2_sky130_fd_sc_hd__fill_1
XFILLER_31_69 vssd1 vccd1 vssd1 vccd1 X2_sky130_ef_sc_hd__decap_40_12
XTAP_TAPCELL_ROW_8_313 vccd1 vssd1 X2_sky130_fd_sc_hd__tapvpwrvgnd_1
Xoutput58 vccd1 vssd1 wbs_dat_o[9] _566_/Q vccd1 vssd1 X2_sky130_fd_sc_hd__buf_2
Xoutput47 vccd1 vssd1 wbs_dat_o[13] _570_/Q vccd1 vssd1 X2_sky130_fd_sc_hd__buf_2
XFILLER_0_279 vccd1 vssd1 vccd1 vssd1 X2_sky130_fd_sc_hd__fill_1
XFILLER_17_615 vccd1 vssd1 vccd1 vssd1 X2_sky130_fd_sc_hd__fill_1
XFILLER_29_497 vssd1 vccd1 vccd1 vssd1 X2_sky130_fd_sc_hd__fill_4
XFILLER_91_529 vssd1 vccd1 vssd1 vccd1 X2_sky130_ef_sc_hd__decap_40_12
XFILLER_84_581 vssd1 vccd1 vccd1 vssd1 X2_sky130_fd_sc_hd__fill_4
X_572_ vssd1 vccd1 vccd1 vssd1 _606_/CLK _572_/D _492_/Y _572_/Q X2_sky130_fd_sc_hd__dfrtp_1
XFILLER_56_77 vssd1 vccd1 vccd1 vssd1 X2_sky130_fd_sc_hd__fill_4
XFILLER_44_401 vssd1 vccd1 vccd1 vssd1 X2_sky130_fd_sc_hd__fill_8
XFILLER_72_65 vssd1 vccd1 vssd1 vccd1 X2_sky130_ef_sc_hd__decap_40_12
XTAP_TAPCELL_ROW_70_988 vccd1 vssd1 X2_sky130_fd_sc_hd__tapvpwrvgnd_1
XTAP_TAPCELL_ROW_42_679 vccd1 vssd1 X2_sky130_fd_sc_hd__tapvpwrvgnd_1
XFILLER_8_357 vssd1 vccd1 vccd1 vssd1 X2_sky130_fd_sc_hd__fill_4
XFILLER_4_585 vssd1 vccd1 vccd1 vssd1 X2_sky130_fd_sc_hd__fill_2
XFILLER_97_51 vssd1 vccd1 vccd1 vssd1 X2_sky130_fd_sc_hd__fill_4
XFILLER_98_139 vccd1 vssd1 vccd1 vssd1 X2_sky130_fd_sc_hd__fill_1
XFILLER_39_217 vssd1 vccd1 vccd1 vssd1 X2_sky130_fd_sc_hd__fill_4
XFILLER_67_559 vccd1 vssd1 vccd1 vssd1 X2_sky130_fd_sc_hd__fill_1
XPHY_EDGE_ROW_6_Left_108 vccd1 vssd1 vccd1 vssd1 X2_sky130_fd_sc_hd__decap_3
XFILLER_94_345 vssd1 vccd1 vssd1 vccd1 X2_sky130_ef_sc_hd__decap_40_12
XFILLER_94_389 vssd1 vccd1 vssd1 vccd1 X2_sky130_ef_sc_hd__decap_40_12
XFILLER_82_529 vssd1 vccd1 vccd1 vssd1 X2_sky130_fd_sc_hd__fill_2
XFILLER_62_253 vssd1 vccd1 vssd1 vccd1 X2_sky130_ef_sc_hd__decap_40_12
XFILLER_50_404 vssd1 vccd1 vssd1 vccd1 X2_sky130_ef_sc_hd__decap_40_12
XFILLER_22_139 vccd1 vssd1 vccd1 vssd1 X2_sky130_fd_sc_hd__fill_1
XFILLER_50_437 vssd1 vccd1 vccd1 vssd1 X2_sky130_fd_sc_hd__fill_2
XFILLER_50_459 vssd1 vccd1 vssd1 vccd1 X2_sky130_ef_sc_hd__decap_40_12
XFILLER_7_93 vssd1 vccd1 vssd1 vccd1 X2_sky130_ef_sc_hd__decap_40_12
XFILLER_97_161 vssd1 vccd1 vccd1 vssd1 X2_sky130_fd_sc_hd__fill_4
XFILLER_100_601 vssd1 vccd1 vssd1 vccd1 X2_sky130_ef_sc_hd__decap_40_12
XFILLER_26_401 vssd1 vccd1 vssd1 vccd1 X2_sky130_ef_sc_hd__decap_40_12
XFILLER_38_261 vssd1 vccd1 vssd1 vccd1 X2_sky130_ef_sc_hd__decap_40_12
XFILLER_85_389 vssd1 vccd1 vccd1 vssd1 X2_sky130_fd_sc_hd__fill_2
XFILLER_73_529 vssd1 vccd1 vssd1 vccd1 X2_sky130_ef_sc_hd__decap_40_12
XFILLER_66_581 vssd1 vccd1 vccd1 vssd1 X2_sky130_fd_sc_hd__fill_4
XFILLER_26_445 vssd1 vccd1 vssd1 vccd1 X2_sky130_ef_sc_hd__decap_40_12
XFILLER_53_220 vssd1 vccd1 vccd1 vssd1 X2_sky130_fd_sc_hd__fill_4
XFILLER_26_489 vssd1 vccd1 vssd1 vccd1 X2_sky130_ef_sc_hd__decap_40_12
XFILLER_81_573 vssd1 vccd1 vssd1 vccd1 X2_sky130_ef_sc_hd__decap_40_12
XFILLER_21_161 vssd1 vccd1 vccd1 vssd1 X2_sky130_fd_sc_hd__fill_4
XFILLER_5_305 vssd1 vccd1 vssd1 vccd1 X2_sky130_ef_sc_hd__decap_40_12
XFILLER_5_349 vssd1 vccd1 vssd1 vccd1 X2_sky130_ef_sc_hd__decap_40_12
XFILLER_101_3 vssd1 vccd1 vssd1 vccd1 X2_sky130_ef_sc_hd__decap_40_12
XFILLER_95_109 vssd1 vccd1 vccd1 vssd1 X2_sky130_fd_sc_hd__fill_2
XFILLER_76_345 vssd1 vccd1 vssd1 vccd1 X2_sky130_ef_sc_hd__decap_40_12
XANTENNA_input21_A wbs_adr_i[7] vssd1 vccd1 vccd1 vssd1 X2_sky130_fd_sc_hd__diode_2
XTAP_TAPCELL_ROW_19_429 vccd1 vssd1 X2_sky130_fd_sc_hd__tapvpwrvgnd_1
XFILLER_29_261 vssd1 vccd1 vccd1 vssd1 X2_sky130_fd_sc_hd__fill_8
XFILLER_76_389 vssd1 vccd1 vssd1 vccd1 X2_sky130_ef_sc_hd__decap_40_12
XFILLER_57_581 vssd1 vccd1 vccd1 vssd1 X2_sky130_fd_sc_hd__fill_2
XTAP_TAPCELL_ROW_47_738 vccd1 vssd1 X2_sky130_fd_sc_hd__tapvpwrvgnd_1
XFILLER_17_445 vssd1 vccd1 vccd1 vssd1 X2_sky130_fd_sc_hd__fill_2
XFILLER_91_337 vccd1 vssd1 vccd1 vssd1 X2_sky130_fd_sc_hd__fill_1
X_555_ vssd1 vccd1 vccd1 vssd1 _599_/CLK _555_/D _475_/Y _555_/Q X2_sky130_fd_sc_hd__dfrtp_1
XFILLER_44_253 vssd1 vccd1 vssd1 vccd1 X2_sky130_ef_sc_hd__decap_40_12
X_486_ vccd1 vssd1 vccd1 vssd1 _486_/Y _521_/A X2_sky130_fd_sc_hd__inv_2
XFILLER_72_595 vssd1 vccd1 vccd1 vssd1 X2_sky130_fd_sc_hd__fill_2
XFILLER_8_121 vssd1 vccd1 vssd1 vccd1 X2_sky130_ef_sc_hd__decap_40_12
XFILLER_8_165 vssd1 vccd1 vssd1 vccd1 X2_sky130_ef_sc_hd__decap_40_12
XFILLER_66_6 vssd1 vccd1 vssd1 vccd1 X2_sky130_ef_sc_hd__decap_40_12
XTAP_TAPCELL_ROW_74_1036 vccd1 vssd1 X2_sky130_fd_sc_hd__tapvpwrvgnd_1
XPHY_EDGE_ROW_97_Left_199 vccd1 vssd1 vccd1 vssd1 X2_sky130_fd_sc_hd__decap_3
XFILLER_101_409 vssd1 vccd1 vccd1 vssd1 X2_sky130_fd_sc_hd__fill_8
XFILLER_86_109 vssd1 vccd1 vssd1 vccd1 X2_sky130_ef_sc_hd__decap_40_12
XFILLER_79_161 vssd1 vccd1 vccd1 vssd1 X2_sky130_fd_sc_hd__fill_4
XFILLER_67_334 vssd1 vccd1 vccd1 vssd1 X2_sky130_fd_sc_hd__fill_2
XFILLER_94_153 vssd1 vccd1 vssd1 vccd1 X2_sky130_ef_sc_hd__decap_40_12
XFILLER_67_389 vssd1 vccd1 vccd1 vssd1 X2_sky130_fd_sc_hd__fill_2
XFILLER_55_529 vssd1 vccd1 vssd1 vccd1 X2_sky130_ef_sc_hd__decap_40_12
XFILLER_35_220 vssd1 vccd1 vccd1 vssd1 X2_sky130_fd_sc_hd__fill_4
XFILLER_94_197 vssd1 vccd1 vssd1 vccd1 X2_sky130_ef_sc_hd__decap_40_12
XTAP_TAPCELL_ROW_85_1154 vccd1 vssd1 X2_sky130_fd_sc_hd__tapvpwrvgnd_1
XFILLER_63_573 vssd1 vccd1 vccd1 vssd1 X2_sky130_fd_sc_hd__fill_2
XFILLER_10_109 vssd1 vccd1 vssd1 vccd1 X2_sky130_ef_sc_hd__decap_40_12
XFILLER_12_27 vccd1 vssd1 vccd1 vssd1 X2_sky130_fd_sc_hd__fill_1
XTAP_TAPCELL_ROW_96_1272 vccd1 vssd1 X2_sky130_fd_sc_hd__tapvpwrvgnd_1
XFILLER_77_109 vssd1 vccd1 vccd1 vssd1 X2_sky130_fd_sc_hd__fill_2
XFILLER_58_345 vssd1 vccd1 vssd1 vccd1 X2_sky130_ef_sc_hd__decap_40_12
XFILLER_18_209 vssd1 vccd1 vssd1 vccd1 X2_sky130_ef_sc_hd__decap_40_12
XFILLER_37_57 vssd1 vccd1 vssd1 vccd1 X2_sky130_ef_sc_hd__decap_40_12
XFILLER_100_475 vccd1 vssd1 vccd1 vssd1 X2_sky130_fd_sc_hd__fill_1
XFILLER_58_389 vssd1 vccd1 vssd1 vccd1 X2_sky130_ef_sc_hd__decap_40_12
XFILLER_46_529 vssd1 vccd1 vccd1 vssd1 X2_sky130_fd_sc_hd__fill_2
XFILLER_73_337 vssd1 vccd1 vssd1 vccd1 X2_sky130_ef_sc_hd__decap_40_12
XFILLER_26_253 vssd1 vccd1 vssd1 vccd1 X2_sky130_ef_sc_hd__decap_40_12
XTAP_TAPCELL_ROW_44_708 vccd1 vssd1 X2_sky130_fd_sc_hd__tapvpwrvgnd_1
X_340_ vccd1 vssd1 vssd1 vccd1 _339_/X _317_/B hold64/X _338_/X _340_/X X2_sky130_fd_sc_hd__o22a_1
XTAP_TAPCELL_ROW_24_487 vccd1 vssd1 X2_sky130_fd_sc_hd__tapvpwrvgnd_1
XFILLER_41_289 vssd1 vccd1 vccd1 vssd1 X2_sky130_fd_sc_hd__fill_2
XTAP_TAPCELL_ROW_52_796 vccd1 vssd1 X2_sky130_fd_sc_hd__tapvpwrvgnd_1
X_271_ vssd1 vccd1 vssd1 vccd1 _304_/A _320_/B _341_/B _341_/C X2_sky130_fd_sc_hd__and3_4
XFILLER_5_113 vssd1 vccd1 vssd1 vccd1 X2_sky130_ef_sc_hd__decap_40_12
XANTENNA__340__A2 _317_/B vssd1 vccd1 vccd1 vssd1 X2_sky130_fd_sc_hd__diode_2
XFILLER_1_352 vssd1 vccd1 vccd1 vssd1 X2_sky130_fd_sc_hd__fill_4
XFILLER_78_53 vssd1 vccd1 vssd1 vccd1 X2_sky130_ef_sc_hd__decap_40_12
XFILLER_68_109 vssd1 vccd1 vssd1 vccd1 X2_sky130_ef_sc_hd__decap_40_12
XFILLER_78_97 vssd1 vccd1 vssd1 vccd1 X2_sky130_ef_sc_hd__decap_40_12
XFILLER_49_345 vssd1 vccd1 vccd1 vssd1 X2_sky130_fd_sc_hd__fill_2
XFILLER_92_613 vssd1 vccd1 vssd1 vccd1 X2_sky130_ef_sc_hd__decap_40_12
XFILLER_94_41 vssd1 vccd1 vssd1 vccd1 X2_sky130_ef_sc_hd__decap_40_12
XFILLER_76_153 vssd1 vccd1 vssd1 vccd1 X2_sky130_ef_sc_hd__decap_40_12
XFILLER_64_315 vccd1 vssd1 vccd1 vssd1 X2_sky130_fd_sc_hd__fill_1
XFILLER_94_85 vssd1 vccd1 vssd1 vccd1 X2_sky130_ef_sc_hd__decap_40_12
XFILLER_76_197 vssd1 vccd1 vssd1 vccd1 X2_sky130_ef_sc_hd__decap_40_12
XFILLER_91_167 vccd1 vssd1 vccd1 vssd1 X2_sky130_fd_sc_hd__fill_1
X_607_ vssd1 vccd1 vccd1 vssd1 _607_/CLK hold3/X _527_/Y _607_/Q X2_sky130_fd_sc_hd__dfrtp_1
XFILLER_45_573 vccd1 vssd1 vccd1 vssd1 X2_sky130_fd_sc_hd__fill_1
X_538_ vssd1 vccd1 vccd1 vssd1 _601_/CLK _538_/D _458_/Y _538_/Q X2_sky130_fd_sc_hd__dfrtp_4
XFILLER_32_289 vssd1 vccd1 vssd1 vccd1 X2_sky130_ef_sc_hd__decap_40_12
XFILLER_60_587 vccd1 vssd1 vccd1 vssd1 X2_sky130_fd_sc_hd__fill_1
X_469_ vccd1 vssd1 vccd1 vssd1 _469_/Y _529_/A X2_sky130_fd_sc_hd__inv_2
XFILLER_9_441 vssd1 vccd1 vccd1 vssd1 X2_sky130_fd_sc_hd__fill_4
XTAP_TAPCELL_ROW_80_1095 vccd1 vssd1 X2_sky130_fd_sc_hd__tapvpwrvgnd_1
XFILLER_9_485 vssd1 vccd1 vssd1 vccd1 X2_sky130_ef_sc_hd__decap_40_12
XANTENNA__462__A _473_/A vssd1 vccd1 vccd1 vssd1 X2_sky130_fd_sc_hd__diode_2
XFILLER_64_3 vccd1 vssd1 vccd1 vssd1 X2_sky130_fd_sc_hd__fill_1
XANTENNA__331__A2 _317_/B vssd1 vccd1 vccd1 vssd1 X2_sky130_fd_sc_hd__diode_2
XFILLER_99_223 vccd1 vssd1 vccd1 vssd1 X2_sky130_fd_sc_hd__fill_1
XFILLER_59_109 vssd1 vccd1 vccd1 vssd1 X2_sky130_fd_sc_hd__fill_2
XFILLER_4_83 vccd1 vssd1 vccd1 vssd1 X2_sky130_fd_sc_hd__fill_1
XFILLER_87_429 vssd1 vccd1 vssd1 vccd1 X2_sky130_ef_sc_hd__decap_40_12
XFILLER_28_529 vssd1 vccd1 vccd1 vssd1 X2_sky130_fd_sc_hd__fill_2
XFILLER_95_473 vssd1 vccd1 vssd1 vccd1 X2_sky130_ef_sc_hd__decap_40_12
XFILLER_83_613 vssd1 vccd1 vccd1 vssd1 X2_sky130_fd_sc_hd__fill_2
XANTENNA__568__CLK _599_/CLK vssd1 vccd1 vccd1 vssd1 X2_sky130_fd_sc_hd__diode_2
XFILLER_55_337 vssd1 vccd1 vssd1 vccd1 X2_sky130_ef_sc_hd__decap_40_12
XFILLER_36_551 vccd1 vssd1 vccd1 vssd1 X2_sky130_fd_sc_hd__fill_1
XFILLER_70_307 vccd1 vssd1 vccd1 vssd1 X2_sky130_fd_sc_hd__fill_1
XFILLER_23_223 vccd1 vssd1 vccd1 vssd1 X2_sky130_fd_sc_hd__fill_1
XFILLER_82_189 vssd1 vccd1 vccd1 vssd1 X2_sky130_fd_sc_hd__fill_4
XFILLER_11_429 vssd1 vccd1 vssd1 vccd1 X2_sky130_ef_sc_hd__decap_40_12
XFILLER_23_15 vssd1 vccd1 vssd1 vccd1 X2_sky130_ef_sc_hd__decap_40_12
XFILLER_51_587 vssd1 vccd1 vccd1 vssd1 X2_sky130_fd_sc_hd__fill_2
XFILLER_51_576 vssd1 vccd1 vccd1 vssd1 X2_sky130_fd_sc_hd__fill_2
XTAP_TAPCELL_ROW_98_1301 vccd1 vssd1 X2_sky130_fd_sc_hd__tapvpwrvgnd_1
XTAP_TAPCELL_ROW_21_446 vccd1 vssd1 X2_sky130_fd_sc_hd__tapvpwrvgnd_1
XFILLER_3_617 vssd1 vccd1 vccd1 vssd1 X2_sky130_fd_sc_hd__fill_8
Xclkbuf_3_0__f_wb_clk_i vssd1 vccd1 vssd1 vccd1 clkbuf_0_wb_clk_i/X _553_/CLK X2_sky130_fd_sc_hd__clkbuf_16
XANTENNA__322__A2 _317_/B vssd1 vccd1 vccd1 vssd1 X2_sky130_fd_sc_hd__diode_2
XFILLER_19_529 vssd1 vccd1 vssd1 vccd1 X2_sky130_ef_sc_hd__decap_40_12
XFILLER_86_473 vssd1 vccd1 vccd1 vssd1 X2_sky130_fd_sc_hd__fill_2
XFILLER_74_624 vccd1 vssd1 vccd1 vssd1 X2_sky130_fd_sc_hd__fill_1
XFILLER_74_613 vssd1 vccd1 vccd1 vssd1 X2_sky130_fd_sc_hd__fill_4
XFILLER_58_153 vssd1 vccd1 vssd1 vccd1 X2_sky130_ef_sc_hd__decap_40_12
XTAP_TAPCELL_ROW_29_535 vccd1 vssd1 X2_sky130_fd_sc_hd__tapvpwrvgnd_1
XFILLER_64_11 vssd1 vccd1 vssd1 vccd1 X2_sky130_ef_sc_hd__decap_40_12
XFILLER_58_197 vssd1 vccd1 vssd1 vccd1 X2_sky130_ef_sc_hd__decap_40_12
XTAP_TAPCELL_ROW_57_844 vccd1 vssd1 X2_sky130_fd_sc_hd__tapvpwrvgnd_1
XFILLER_73_167 vccd1 vssd1 vccd1 vssd1 X2_sky130_fd_sc_hd__fill_1
XFILLER_27_573 vssd1 vccd1 vssd1 vccd1 X2_sky130_ef_sc_hd__decap_40_12
XFILLER_64_77 vssd1 vccd1 vccd1 vssd1 X2_sky130_fd_sc_hd__fill_4
XFILLER_14_245 vssd1 vccd1 vccd1 vssd1 X2_sky130_fd_sc_hd__fill_4
XFILLER_42_554 vccd1 vssd1 vccd1 vssd1 X2_sky130_fd_sc_hd__fill_1
XFILLER_9_39 vssd1 vccd1 vssd1 vccd1 X2_sky130_ef_sc_hd__decap_40_12
XFILLER_14_289 vssd1 vccd1 vssd1 vccd1 X2_sky130_ef_sc_hd__decap_40_12
X_323_ vccd1 vssd1 vccd1 vssd1 _320_/X _596_/Q _304_/A _323_/X hold48/X X2_sky130_fd_sc_hd__a22o_1
XFILLER_42_576 vssd1 vccd1 vccd1 vssd1 X2_sky130_fd_sc_hd__fill_2
Xfanout60 vccd1 vssd1 vssd1 vccd1 _521_/A _473_/A X2_sky130_fd_sc_hd__buf_8
XFILLER_80_65 vssd1 vccd1 vssd1 vccd1 X2_sky130_ef_sc_hd__decap_40_12
XFILLER_6_433 vssd1 vccd1 vssd1 vccd1 X2_sky130_ef_sc_hd__decap_40_12
XFILLER_10_473 vssd1 vccd1 vccd1 vssd1 X2_sky130_fd_sc_hd__fill_2
XFILLER_13_81 vssd1 vccd1 vssd1 vccd1 X2_sky130_ef_sc_hd__decap_40_12
XFILLER_6_477 vssd1 vccd1 vssd1 vccd1 X2_sky130_ef_sc_hd__decap_40_12
XTAP_TAPCELL_ROW_71_1006 vccd1 vssd1 X2_sky130_fd_sc_hd__tapvpwrvgnd_1
XFILLER_69_429 vssd1 vccd1 vssd1 vccd1 X2_sky130_ef_sc_hd__decap_40_12
XFILLER_1_193 vssd1 vccd1 vssd1 vccd1 X2_sky130_ef_sc_hd__decap_40_12
XFILLER_77_473 vssd1 vccd1 vssd1 vccd1 X2_sky130_ef_sc_hd__decap_40_12
XFILLER_65_624 vccd1 vssd1 vccd1 vssd1 X2_sky130_fd_sc_hd__fill_1
XFILLER_37_337 vccd1 vssd1 vccd1 vssd1 X2_sky130_fd_sc_hd__fill_1
XFILLER_92_421 vssd1 vccd1 vssd1 vccd1 X2_sky130_ef_sc_hd__decap_40_12
XANTENNA__457__A _473_/A vssd1 vccd1 vccd1 vssd1 X2_sky130_fd_sc_hd__diode_2
XFILLER_64_189 vssd1 vccd1 vccd1 vssd1 X2_sky130_fd_sc_hd__fill_4
XTAP_TAPCELL_ROW_82_1124 vccd1 vssd1 X2_sky130_fd_sc_hd__tapvpwrvgnd_1
XFILLER_60_340 vssd1 vccd1 vccd1 vssd1 X2_sky130_fd_sc_hd__fill_2
XFILLER_33_576 vssd1 vccd1 vccd1 vssd1 X2_sky130_fd_sc_hd__fill_2
XFILLER_33_598 vssd1 vccd1 vccd1 vssd1 X2_sky130_fd_sc_hd__fill_2
XFILLER_60_362 vssd1 vccd1 vccd1 vssd1 X2_sky130_fd_sc_hd__fill_2
XFILLER_9_293 vssd1 vccd1 vssd1 vccd1 X2_sky130_ef_sc_hd__decap_40_12
XTAP_TAPCELL_ROW_93_1242 vccd1 vssd1 X2_sky130_fd_sc_hd__tapvpwrvgnd_1
XFILLER_87_237 vssd1 vccd1 vssd1 vccd1 X2_sky130_ef_sc_hd__decap_40_12
XFILLER_18_15 vssd1 vccd1 vssd1 vccd1 X2_sky130_ef_sc_hd__decap_40_12
XFILLER_68_473 vssd1 vccd1 vccd1 vssd1 X2_sky130_fd_sc_hd__fill_2
XFILLER_56_624 vccd1 vssd1 vccd1 vssd1 X2_sky130_fd_sc_hd__fill_1
XFILLER_95_281 vssd1 vccd1 vssd1 vccd1 X2_sky130_ef_sc_hd__decap_40_12
XFILLER_55_167 vccd1 vssd1 vccd1 vssd1 X2_sky130_fd_sc_hd__fill_1
XTAP_TAPCELL_ROW_26_505 vccd1 vssd1 X2_sky130_fd_sc_hd__tapvpwrvgnd_1
XTAP_TAPCELL_ROW_54_814 vccd1 vssd1 X2_sky130_fd_sc_hd__tapvpwrvgnd_1
XFILLER_70_137 vssd1 vccd1 vccd1 vssd1 X2_sky130_fd_sc_hd__fill_2
XFILLER_24_587 vccd1 vssd1 vccd1 vssd1 X2_sky130_fd_sc_hd__fill_1
XFILLER_51_373 vssd1 vccd1 vssd1 vccd1 X2_sky130_ef_sc_hd__decap_40_12
XFILLER_11_237 vssd1 vccd1 vssd1 vccd1 X2_sky130_ef_sc_hd__decap_40_12
XTAP_TAPCELL_ROW_34_593 vccd1 vssd1 X2_sky130_fd_sc_hd__tapvpwrvgnd_1
Xclkload2 vssd1 vccd1 vccd1 vssd1 _601_/CLK clkload2/Y X2_sky130_fd_sc_hd__clkinv_4
XFILLER_3_447 vccd1 vssd1 vccd1 vssd1 X2_sky130_fd_sc_hd__fill_1
XFILLER_59_55 vccd1 vssd1 vccd1 vssd1 X2_sky130_fd_sc_hd__fill_1
XTAP_TAPCELL_ROW_6_285 vccd1 vssd1 X2_sky130_fd_sc_hd__tapvpwrvgnd_1
XFILLER_59_473 vssd1 vccd1 vssd1 vccd1 X2_sky130_ef_sc_hd__decap_40_12
XFILLER_19_337 vssd1 vccd1 vssd1 vccd1 X2_sky130_ef_sc_hd__decap_40_12
XFILLER_74_421 vssd1 vccd1 vssd1 vccd1 X2_sky130_ef_sc_hd__decap_40_12
XFILLER_47_624 vccd1 vssd1 vccd1 vssd1 X2_sky130_fd_sc_hd__fill_1
XFILLER_34_307 vccd1 vssd1 vccd1 vssd1 X2_sky130_fd_sc_hd__fill_1
XFILLER_62_605 vssd1 vccd1 vccd1 vssd1 X2_sky130_fd_sc_hd__fill_2
XFILLER_46_189 vccd1 vssd1 vccd1 vssd1 X2_sky130_fd_sc_hd__fill_1
XFILLER_61_137 vssd1 vccd1 vssd1 vccd1 X2_sky130_ef_sc_hd__decap_40_12
XFILLER_30_513 vssd1 vccd1 vssd1 vccd1 X2_sky130_ef_sc_hd__decap_40_12
X_306_ vccd1 vssd1 vccd1 vssd1 _304_/X _571_/Q _303_/X _306_/X hold11/X X2_sky130_fd_sc_hd__a22o_1
XFILLER_30_557 vssd1 vccd1 vssd1 vccd1 X2_sky130_ef_sc_hd__decap_40_12
XFILLER_97_557 vssd1 vccd1 vccd1 vssd1 X2_sky130_fd_sc_hd__fill_2
XFILLER_69_237 vssd1 vccd1 vssd1 vccd1 X2_sky130_ef_sc_hd__decap_40_12
XFILLER_27_3 vssd1 vccd1 vssd1 vccd1 X2_sky130_ef_sc_hd__decap_40_12
XFILLER_38_624 vccd1 vssd1 vccd1 vssd1 X2_sky130_fd_sc_hd__fill_1
XFILLER_77_281 vssd1 vccd1 vssd1 vccd1 X2_sky130_ef_sc_hd__decap_40_12
XFILLER_1_51 vssd1 vccd1 vccd1 vssd1 X2_sky130_fd_sc_hd__fill_4
XFILLER_92_251 vccd1 vssd1 vccd1 vssd1 X2_sky130_fd_sc_hd__fill_1
XFILLER_25_329 vssd1 vccd1 vccd1 vssd1 X2_sky130_fd_sc_hd__fill_4
XFILLER_37_167 vccd1 vssd1 vccd1 vssd1 X2_sky130_fd_sc_hd__fill_1
XFILLER_92_273 vssd1 vccd1 vssd1 vccd1 X2_sky130_ef_sc_hd__decap_40_12
XFILLER_80_413 vssd1 vccd1 vccd1 vssd1 X2_sky130_fd_sc_hd__fill_4
XFILLER_80_457 vssd1 vccd1 vssd1 vccd1 X2_sky130_ef_sc_hd__decap_40_12
XFILLER_52_137 vssd1 vccd1 vccd1 vssd1 X2_sky130_fd_sc_hd__fill_2
XFILLER_33_373 vssd1 vccd1 vccd1 vssd1 X2_sky130_fd_sc_hd__fill_2
XANTENNA__606__CLK _606_/CLK vssd1 vccd1 vccd1 vssd1 X2_sky130_fd_sc_hd__diode_2
XFILLER_21_557 vssd1 vccd1 vccd1 vssd1 X2_sky130_fd_sc_hd__fill_2
XTAP_TAPCELL_ROW_31_563 vccd1 vssd1 X2_sky130_fd_sc_hd__tapvpwrvgnd_1
XFILLER_20_27 vccd1 vssd1 vccd1 vssd1 X2_sky130_fd_sc_hd__fill_1
XFILLER_88_513 vssd1 vccd1 vssd1 vccd1 X2_sky130_ef_sc_hd__decap_40_12
XFILLER_88_557 vssd1 vccd1 vssd1 vccd1 X2_sky130_ef_sc_hd__decap_40_12
Xhold14 _569_/D _308_/X vccd1 vssd1 vssd1 vccd1 X2_sky130_fd_sc_hd__dlygate4sd3_1
XFILLER_29_69 vssd1 vccd1 vssd1 vccd1 X2_sky130_ef_sc_hd__decap_40_12
XFILLER_29_613 vssd1 vccd1 vccd1 vssd1 X2_sky130_fd_sc_hd__fill_2
Xhold36 hold36/X _587_/Q vccd1 vssd1 vssd1 vccd1 X2_sky130_fd_sc_hd__dlygate4sd3_1
Xhold47 hold47/X _586_/Q vccd1 vssd1 vssd1 vccd1 X2_sky130_fd_sc_hd__dlygate4sd3_1
Xhold25 hold25/X _601_/Q vccd1 vssd1 vssd1 vccd1 X2_sky130_fd_sc_hd__dlygate4sd3_1
XFILLER_29_624 vccd1 vssd1 vccd1 vssd1 X2_sky130_fd_sc_hd__fill_1
Xhold69 hold69/X _599_/Q vccd1 vssd1 vssd1 vccd1 X2_sky130_fd_sc_hd__dlygate4sd3_1
XFILLER_56_421 vssd1 vccd1 vssd1 vccd1 X2_sky130_ef_sc_hd__decap_40_12
Xhold58 _559_/D _337_/X vccd1 vssd1 vssd1 vccd1 X2_sky130_fd_sc_hd__dlygate4sd3_1
XTAP_TAPCELL_ROW_3_255 vccd1 vssd1 X2_sky130_fd_sc_hd__tapvpwrvgnd_1
XTAP_TAPCELL_ROW_39_652 vccd1 vssd1 X2_sky130_fd_sc_hd__tapvpwrvgnd_1
XTAP_TAPCELL_ROW_67_961 vccd1 vssd1 X2_sky130_fd_sc_hd__tapvpwrvgnd_1
XFILLER_16_307 vccd1 vssd1 vccd1 vssd1 X2_sky130_fd_sc_hd__fill_1
XFILLER_28_189 vssd1 vccd1 vccd1 vssd1 X2_sky130_fd_sc_hd__fill_4
XFILLER_83_273 vccd1 vssd1 vccd1 vssd1 X2_sky130_fd_sc_hd__fill_1
XFILLER_45_57 vssd1 vccd1 vssd1 vccd1 X2_sky130_ef_sc_hd__decap_40_12
XFILLER_43_137 vssd1 vccd1 vssd1 vccd1 X2_sky130_ef_sc_hd__decap_40_12
XFILLER_101_41 vssd1 vccd1 vssd1 vccd1 X2_sky130_ef_sc_hd__decap_40_12
XFILLER_12_513 vssd1 vccd1 vssd1 vccd1 X2_sky130_ef_sc_hd__decap_40_12
XFILLER_101_85 vssd1 vccd1 vssd1 vccd1 X2_sky130_ef_sc_hd__decap_40_12
XTAP_TAPCELL_ROW_100_1319 vccd1 vssd1 X2_sky130_fd_sc_hd__tapvpwrvgnd_1
XFILLER_51_181 vssd1 vccd1 vssd1 vccd1 X2_sky130_ef_sc_hd__decap_40_12
XFILLER_12_557 vssd1 vccd1 vssd1 vccd1 X2_sky130_ef_sc_hd__decap_40_12
XFILLER_6_29 vssd1 vccd1 vssd1 vccd1 X2_sky130_ef_sc_hd__decap_40_12
XFILLER_3_277 vssd1 vccd1 vccd1 vssd1 X2_sky130_fd_sc_hd__fill_2
XFILLER_79_557 vssd1 vccd1 vccd1 vssd1 X2_sky130_fd_sc_hd__fill_2
XFILLER_86_53 vssd1 vccd1 vssd1 vccd1 X2_sky130_ef_sc_hd__decap_40_12
XFILLER_86_97 vssd1 vccd1 vssd1 vccd1 X2_sky130_ef_sc_hd__decap_40_12
XFILLER_59_281 vssd1 vccd1 vssd1 vccd1 X2_sky130_ef_sc_hd__decap_40_12
XFILLER_47_432 vccd1 vssd1 vccd1 vssd1 X2_sky130_fd_sc_hd__fill_1
XFILLER_19_167 vccd1 vssd1 vccd1 vssd1 X2_sky130_fd_sc_hd__fill_1
XFILLER_74_251 vccd1 vssd1 vccd1 vssd1 X2_sky130_fd_sc_hd__fill_1
XFILLER_62_413 vssd1 vccd1 vccd1 vssd1 X2_sky130_fd_sc_hd__fill_4
XFILLER_34_137 vssd1 vccd1 vccd1 vssd1 X2_sky130_fd_sc_hd__fill_2
XFILLER_62_457 vssd1 vccd1 vssd1 vccd1 X2_sky130_ef_sc_hd__decap_40_12
XFILLER_50_619 vccd1 vssd1 vccd1 vssd1 X2_sky130_fd_sc_hd__fill_1
XFILLER_15_373 vssd1 vccd1 vssd1 vccd1 X2_sky130_ef_sc_hd__decap_40_12
XFILLER_30_354 vssd1 vccd1 vccd1 vssd1 X2_sky130_fd_sc_hd__fill_8
XFILLER_30_365 vssd1 vccd1 vssd1 vccd1 X2_sky130_ef_sc_hd__decap_40_12
XFILLER_7_561 vssd1 vccd1 vssd1 vccd1 X2_sky130_ef_sc_hd__decap_40_12
XANTENNA__470__A _473_/A vssd1 vccd1 vccd1 vssd1 X2_sky130_fd_sc_hd__diode_2
XTAP_TAPCELL_ROW_77_1067 vccd1 vssd1 X2_sky130_fd_sc_hd__tapvpwrvgnd_1
XTAP_TAPCELL_ROW_90_1212 vccd1 vssd1 X2_sky130_fd_sc_hd__tapvpwrvgnd_1
XFILLER_97_332 vssd1 vccd1 vccd1 vssd1 X2_sky130_fd_sc_hd__fill_4
XFILLER_85_505 vssd1 vccd1 vssd1 vccd1 X2_sky130_ef_sc_hd__decap_40_12
XFILLER_38_421 vccd1 vssd1 vccd1 vssd1 X2_sky130_fd_sc_hd__fill_1
XFILLER_97_387 vssd1 vccd1 vccd1 vssd1 X2_sky130_fd_sc_hd__fill_4
XFILLER_38_432 vccd1 vssd1 vccd1 vssd1 X2_sky130_fd_sc_hd__fill_1
XTAP_TAPCELL_ROW_0_214 vccd1 vssd1 X2_sky130_fd_sc_hd__tapvpwrvgnd_1
XTAP_TAPCELL_ROW_0_225 vccd1 vssd1 X2_sky130_fd_sc_hd__tapvpwrvgnd_1
XTAP_TAPCELL_ROW_36_611 vccd1 vssd1 X2_sky130_fd_sc_hd__tapvpwrvgnd_1
XFILLER_38_498 vssd1 vccd1 vssd1 vccd1 X2_sky130_ef_sc_hd__decap_40_12
XTAP_TAPCELL_ROW_64_920 vccd1 vssd1 X2_sky130_fd_sc_hd__tapvpwrvgnd_1
XFILLER_25_137 vssd1 vccd1 vssd1 vccd1 X2_sky130_ef_sc_hd__decap_40_12
XTAP_TAPCELL_ROW_88_1185 vccd1 vssd1 X2_sky130_fd_sc_hd__tapvpwrvgnd_1
XFILLER_80_221 vssd1 vccd1 vssd1 vccd1 X2_sky130_ef_sc_hd__decap_40_12
XFILLER_65_295 vssd1 vccd1 vccd1 vssd1 X2_sky130_fd_sc_hd__fill_2
XFILLER_53_446 vssd1 vccd1 vccd1 vssd1 X2_sky130_fd_sc_hd__fill_2
XFILLER_15_27 vssd1 vccd1 vssd1 vccd1 X2_sky130_ef_sc_hd__decap_40_12
XFILLER_80_265 vssd1 vccd1 vssd1 vccd1 X2_sky130_ef_sc_hd__decap_40_12
XFILLER_33_181 vssd1 vccd1 vssd1 vccd1 X2_sky130_ef_sc_hd__decap_40_12
XFILLER_31_15 vssd1 vccd1 vssd1 vccd1 X2_sky130_ef_sc_hd__decap_40_12
XPHY_EDGE_ROW_1_Right_1 vccd1 vssd1 vccd1 vssd1 X2_sky130_fd_sc_hd__decap_3
XTAP_TAPCELL_ROW_8_303 vccd1 vssd1 X2_sky130_fd_sc_hd__tapvpwrvgnd_1
Xoutput48 vccd1 vssd1 wbs_dat_o[14] _571_/Q vccd1 vssd1 X2_sky130_fd_sc_hd__buf_2
XFILLER_0_225 vssd1 vccd1 vssd1 vccd1 X2_sky130_ef_sc_hd__decap_40_12
XFILLER_88_321 vssd1 vccd1 vssd1 vccd1 X2_sky130_ef_sc_hd__decap_40_12
XFILLER_0_258 vssd1 vccd1 vccd1 vssd1 X2_sky130_fd_sc_hd__fill_4
XFILLER_88_365 vccd1 vssd1 vccd1 vssd1 X2_sky130_fd_sc_hd__fill_1
X_571_ vssd1 vccd1 vccd1 vssd1 _606_/CLK _571_/D _491_/Y _571_/Q X2_sky130_fd_sc_hd__dfrtp_1
XFILLER_56_251 vccd1 vssd1 vccd1 vssd1 X2_sky130_fd_sc_hd__fill_1
XFILLER_16_137 vssd1 vccd1 vccd1 vssd1 X2_sky130_fd_sc_hd__fill_2
XFILLER_71_221 vssd1 vccd1 vccd1 vssd1 X2_sky130_fd_sc_hd__fill_2
XFILLER_32_608 vssd1 vccd1 vccd1 vssd1 X2_sky130_fd_sc_hd__fill_8
XFILLER_12_321 vssd1 vccd1 vssd1 vccd1 X2_sky130_ef_sc_hd__decap_40_12
XFILLER_72_77 vssd1 vccd1 vccd1 vssd1 X2_sky130_fd_sc_hd__fill_4
XTAP_TAPCELL_ROW_70_989 vccd1 vssd1 X2_sky130_fd_sc_hd__tapvpwrvgnd_1
XFILLER_12_365 vssd1 vccd1 vssd1 vccd1 X2_sky130_ef_sc_hd__decap_40_12
XFILLER_4_531 vccd1 vssd1 vccd1 vssd1 X2_sky130_fd_sc_hd__fill_1
XFILLER_21_81 vssd1 vccd1 vssd1 vccd1 X2_sky130_ef_sc_hd__decap_40_12
XFILLER_67_505 vssd1 vccd1 vssd1 vccd1 X2_sky130_ef_sc_hd__decap_40_12
XFILLER_94_357 vssd1 vccd1 vccd1 vssd1 X2_sky130_fd_sc_hd__fill_4
XFILLER_35_446 vssd1 vccd1 vccd1 vssd1 X2_sky130_fd_sc_hd__fill_2
XFILLER_62_265 vssd1 vccd1 vssd1 vccd1 X2_sky130_ef_sc_hd__decap_40_12
XFILLER_50_416 vssd1 vccd1 vccd1 vssd1 X2_sky130_fd_sc_hd__fill_4
XFILLER_90_585 vssd1 vccd1 vccd1 vssd1 X2_sky130_fd_sc_hd__fill_2
XFILLER_15_181 vssd1 vccd1 vssd1 vccd1 X2_sky130_ef_sc_hd__decap_40_12
XFILLER_94_3 vssd1 vccd1 vssd1 vccd1 X2_sky130_ef_sc_hd__decap_40_12
XTAP_TAPCELL_ROW_13_360 vccd1 vssd1 X2_sky130_fd_sc_hd__tapvpwrvgnd_1
XFILLER_30_195 vccd1 vssd1 vccd1 vssd1 X2_sky130_fd_sc_hd__fill_1
XFILLER_7_391 vccd1 vssd1 vccd1 vssd1 X2_sky130_fd_sc_hd__fill_1
XFILLER_100_613 vssd1 vccd1 vssd1 vccd1 X2_sky130_ef_sc_hd__decap_40_12
XFILLER_26_15 vssd1 vccd1 vssd1 vccd1 X2_sky130_ef_sc_hd__decap_40_12
XFILLER_26_413 vssd1 vccd1 vccd1 vssd1 X2_sky130_fd_sc_hd__fill_4
XFILLER_38_251 vccd1 vssd1 vccd1 vssd1 X2_sky130_fd_sc_hd__fill_1
XFILLER_38_273 vssd1 vccd1 vccd1 vssd1 X2_sky130_fd_sc_hd__fill_8
XFILLER_81_541 vssd1 vccd1 vssd1 vccd1 X2_sky130_ef_sc_hd__decap_40_12
XFILLER_53_210 vccd1 vssd1 vccd1 vssd1 X2_sky130_fd_sc_hd__fill_1
XFILLER_26_457 vssd1 vccd1 vssd1 vccd1 X2_sky130_ef_sc_hd__decap_40_12
XFILLER_41_405 vssd1 vccd1 vssd1 vccd1 X2_sky130_ef_sc_hd__decap_40_12
XFILLER_81_585 vssd1 vccd1 vssd1 vccd1 X2_sky130_ef_sc_hd__decap_40_12
XFILLER_41_449 vccd1 vssd1 vccd1 vssd1 X2_sky130_fd_sc_hd__fill_1
XFILLER_5_317 vssd1 vccd1 vssd1 vccd1 X2_sky130_ef_sc_hd__decap_40_12
XFILLER_1_501 vssd1 vccd1 vccd1 vssd1 X2_sky130_fd_sc_hd__fill_2
XFILLER_67_11 vssd1 vccd1 vssd1 vccd1 X2_sky130_ef_sc_hd__decap_40_12
XFILLER_49_505 vssd1 vccd1 vccd1 vssd1 X2_sky130_fd_sc_hd__fill_8
XFILLER_67_55 vccd1 vssd1 vccd1 vssd1 X2_sky130_fd_sc_hd__fill_1
XFILLER_49_516 vssd1 vccd1 vccd1 vssd1 X2_sky130_fd_sc_hd__fill_2
XFILLER_88_195 vccd1 vssd1 vccd1 vssd1 X2_sky130_fd_sc_hd__fill_1
XFILLER_76_357 vssd1 vccd1 vccd1 vssd1 X2_sky130_fd_sc_hd__fill_4
XANTENNA_input14_A wbs_adr_i[0] vssd1 vccd1 vccd1 vssd1 X2_sky130_fd_sc_hd__diode_2
XTAP_TAPCELL_ROW_47_739 vccd1 vssd1 X2_sky130_fd_sc_hd__tapvpwrvgnd_1
X_554_ vssd1 vccd1 vccd1 vssd1 _601_/CLK _554_/D _474_/Y _554_/Q X2_sky130_fd_sc_hd__dfrtp_1
XFILLER_44_265 vssd1 vccd1 vssd1 vccd1 X2_sky130_ef_sc_hd__decap_40_12
X_485_ vccd1 vssd1 vccd1 vssd1 _485_/Y _521_/A X2_sky130_fd_sc_hd__inv_2
XFILLER_72_585 vssd1 vccd1 vccd1 vssd1 X2_sky130_fd_sc_hd__fill_2
XFILLER_16_81 vssd1 vccd1 vccd1 vssd1 X2_sky130_fd_sc_hd__fill_2
XFILLER_8_133 vssd1 vccd1 vccd1 vssd1 X2_sky130_fd_sc_hd__fill_4
XFILLER_12_195 vccd1 vssd1 vccd1 vssd1 X2_sky130_fd_sc_hd__fill_1
XFILLER_8_177 vssd1 vccd1 vssd1 vccd1 X2_sky130_ef_sc_hd__decap_40_12
XTAP_TAPCELL_ROW_10_330 vccd1 vssd1 X2_sky130_fd_sc_hd__tapvpwrvgnd_1
XANTENNA__291__Y _299_/S vssd1 vccd1 vccd1 vssd1 X2_sky130_fd_sc_hd__diode_2
XANTENNA__343__B1 _291_/B vssd1 vccd1 vccd1 vssd1 X2_sky130_fd_sc_hd__diode_2
XFILLER_4_361 vssd1 vccd1 vccd1 vssd1 X2_sky130_fd_sc_hd__fill_2
XTAP_TAPCELL_ROW_74_1037 vccd1 vssd1 X2_sky130_fd_sc_hd__tapvpwrvgnd_1
XFILLER_99_449 vssd1 vccd1 vssd1 vccd1 X2_sky130_ef_sc_hd__decap_40_12
XFILLER_67_302 vssd1 vccd1 vssd1 vccd1 X2_sky130_ef_sc_hd__decap_40_12
XFILLER_94_121 vssd1 vccd1 vssd1 vccd1 X2_sky130_ef_sc_hd__decap_40_12
XFILLER_94_165 vssd1 vccd1 vssd1 vccd1 X2_sky130_ef_sc_hd__decap_40_12
XFILLER_82_305 vssd1 vccd1 vccd1 vssd1 X2_sky130_fd_sc_hd__fill_2
XFILLER_23_405 vssd1 vccd1 vssd1 vccd1 X2_sky130_ef_sc_hd__decap_40_12
XFILLER_35_254 vssd1 vccd1 vssd1 vccd1 X2_sky130_ef_sc_hd__decap_40_12
XTAP_TAPCELL_ROW_85_1155 vccd1 vssd1 X2_sky130_fd_sc_hd__tapvpwrvgnd_1
XFILLER_63_541 vssd1 vccd1 vssd1 vccd1 X2_sky130_ef_sc_hd__decap_40_12
XFILLER_35_298 vssd1 vccd1 vssd1 vccd1 X2_sky130_ef_sc_hd__decap_40_12
XFILLER_63_585 vssd1 vccd1 vccd1 vssd1 X2_sky130_fd_sc_hd__fill_4
XFILLER_23_449 vssd1 vccd1 vssd1 vccd1 X2_sky130_ef_sc_hd__decap_40_12
XFILLER_50_246 vssd1 vccd1 vccd1 vssd1 X2_sky130_fd_sc_hd__fill_2
XFILLER_2_309 vssd1 vccd1 vssd1 vccd1 X2_sky130_ef_sc_hd__decap_40_12
XTAP_TAPCELL_ROW_96_1273 vccd1 vssd1 X2_sky130_fd_sc_hd__tapvpwrvgnd_1
XANTENNA_input6_A adc_data_in[3] vssd1 vccd1 vccd1 vssd1 X2_sky130_fd_sc_hd__diode_2
XFILLER_98_471 vssd1 vccd1 vccd1 vssd1 X2_sky130_fd_sc_hd__fill_4
XFILLER_100_421 vssd1 vccd1 vssd1 vccd1 X2_sky130_ef_sc_hd__decap_40_12
XFILLER_58_357 vssd1 vccd1 vccd1 vssd1 X2_sky130_fd_sc_hd__fill_4
XFILLER_85_165 vssd1 vccd1 vccd1 vssd1 X2_sky130_fd_sc_hd__fill_2
XFILLER_73_305 vssd1 vccd1 vssd1 vccd1 X2_sky130_ef_sc_hd__decap_40_12
XFILLER_26_221 vssd1 vccd1 vssd1 vccd1 X2_sky130_ef_sc_hd__decap_40_12
XFILLER_37_69 vssd1 vccd1 vssd1 vccd1 X2_sky130_ef_sc_hd__decap_40_12
XFILLER_73_349 vssd1 vccd1 vssd1 vccd1 X2_sky130_ef_sc_hd__decap_40_12
XFILLER_54_530 vssd1 vccd1 vccd1 vssd1 X2_sky130_fd_sc_hd__fill_2
XFILLER_54_541 vssd1 vccd1 vccd1 vssd1 X2_sky130_fd_sc_hd__fill_2
XTAP_TAPCELL_ROW_44_709 vccd1 vssd1 X2_sky130_fd_sc_hd__tapvpwrvgnd_1
XFILLER_26_265 vssd1 vccd1 vssd1 vccd1 X2_sky130_ef_sc_hd__decap_40_12
XFILLER_41_213 vssd1 vccd1 vccd1 vssd1 X2_sky130_fd_sc_hd__fill_2
XFILLER_54_574 vssd1 vccd1 vssd1 vccd1 X2_sky130_ef_sc_hd__decap_40_12
XFILLER_41_235 vccd1 vssd1 vccd1 vssd1 X2_sky130_fd_sc_hd__fill_1
XFILLER_81_393 vssd1 vccd1 vssd1 vccd1 X2_sky130_ef_sc_hd__decap_40_12
XFILLER_53_57 vssd1 vccd1 vssd1 vccd1 X2_sky130_ef_sc_hd__decap_40_12
XFILLER_41_279 vccd1 vssd1 vccd1 vssd1 X2_sky130_fd_sc_hd__fill_1
X_270_ vssd1 vccd1 vssd1 vccd1 _270_/B _309_/C _341_/C _309_/A _309_/B X2_sky130_fd_sc_hd__nor4_2
XTAP_TAPCELL_ROW_24_488 vccd1 vssd1 X2_sky130_fd_sc_hd__tapvpwrvgnd_1
XTAP_TAPCELL_ROW_52_797 vccd1 vssd1 X2_sky130_fd_sc_hd__tapvpwrvgnd_1
XFILLER_5_125 vssd1 vccd1 vssd1 vccd1 X2_sky130_ef_sc_hd__decap_40_12
XFILLER_5_169 vssd1 vccd1 vssd1 vccd1 X2_sky130_ef_sc_hd__decap_40_12
XFILLER_96_408 vccd1 vssd1 vccd1 vssd1 X2_sky130_fd_sc_hd__fill_1
XFILLER_96_419 vccd1 vssd1 vccd1 vssd1 X2_sky130_fd_sc_hd__fill_1
XFILLER_78_65 vssd1 vccd1 vssd1 vccd1 X2_sky130_ef_sc_hd__decap_40_12
XFILLER_76_121 vssd1 vccd1 vssd1 vccd1 X2_sky130_ef_sc_hd__decap_40_12
XFILLER_49_335 vccd1 vssd1 vccd1 vssd1 X2_sky130_fd_sc_hd__fill_1
XFILLER_94_53 vssd1 vccd1 vssd1 vccd1 X2_sky130_ef_sc_hd__decap_40_12
XFILLER_76_165 vssd1 vccd1 vssd1 vccd1 X2_sky130_ef_sc_hd__decap_40_12
XFILLER_49_368 vssd1 vccd1 vssd1 vccd1 X2_sky130_ef_sc_hd__decap_40_12
XFILLER_17_221 vssd1 vccd1 vccd1 vssd1 X2_sky130_fd_sc_hd__fill_2
XFILLER_91_113 vssd1 vccd1 vssd1 vccd1 X2_sky130_ef_sc_hd__decap_40_12
XFILLER_94_97 vssd1 vccd1 vssd1 vccd1 X2_sky130_ef_sc_hd__decap_40_12
X_606_ vssd1 vccd1 vccd1 vssd1 _606_/CLK _606_/D _526_/Y _606_/Q X2_sky130_fd_sc_hd__dfrtp_1
XFILLER_45_552 vssd1 vccd1 vccd1 vssd1 X2_sky130_fd_sc_hd__fill_8
X_537_ vssd1 vccd1 vccd1 vssd1 _553_/CLK _537_/D _457_/Y _537_/Q X2_sky130_fd_sc_hd__dfrtp_4
XFILLER_60_533 vssd1 vccd1 vssd1 vccd1 X2_sky130_ef_sc_hd__decap_40_12
XFILLER_20_419 vccd1 vssd1 vccd1 vssd1 X2_sky130_fd_sc_hd__fill_1
X_468_ vccd1 vssd1 vccd1 vssd1 _468_/Y _473_/A X2_sky130_fd_sc_hd__inv_2
XTAP_TAPCELL_ROW_80_1096 vccd1 vssd1 X2_sky130_fd_sc_hd__tapvpwrvgnd_1
X_399_ vccd1 vssd1 vssd1 vccd1 _400_/B _416_/B _406_/C X2_sky130_fd_sc_hd__nor2_1
XFILLER_9_497 vssd1 vccd1 vccd1 vssd1 X2_sky130_fd_sc_hd__fill_4
XANTENNA__316__B1 _304_/X vssd1 vccd1 vccd1 vssd1 X2_sky130_fd_sc_hd__diode_2
XFILLER_57_3 vssd1 vccd1 vssd1 vccd1 X2_sky130_ef_sc_hd__decap_40_12
XFILLER_99_279 vccd1 vssd1 vccd1 vssd1 X2_sky130_fd_sc_hd__fill_1
XFILLER_95_441 vssd1 vccd1 vccd1 vssd1 X2_sky130_fd_sc_hd__fill_4
XFILLER_95_485 vssd1 vccd1 vssd1 vccd1 X2_sky130_ef_sc_hd__decap_40_12
XFILLER_67_165 vssd1 vccd1 vccd1 vssd1 X2_sky130_fd_sc_hd__fill_2
XFILLER_55_349 vssd1 vccd1 vssd1 vccd1 X2_sky130_ef_sc_hd__decap_40_12
XFILLER_36_574 vccd1 vssd1 vccd1 vssd1 X2_sky130_fd_sc_hd__fill_1
XFILLER_36_585 vssd1 vccd1 vccd1 vssd1 X2_sky130_fd_sc_hd__fill_2
XFILLER_63_393 vssd1 vccd1 vssd1 vccd1 X2_sky130_ef_sc_hd__decap_40_12
XFILLER_23_27 vssd1 vccd1 vssd1 vccd1 X2_sky130_ef_sc_hd__decap_40_12
XFILLER_23_279 vccd1 vssd1 vccd1 vssd1 X2_sky130_fd_sc_hd__fill_1
XTAP_TAPCELL_ROW_98_1302 vccd1 vssd1 X2_sky130_fd_sc_hd__tapvpwrvgnd_1
XTAP_TAPCELL_ROW_21_447 vccd1 vssd1 X2_sky130_fd_sc_hd__tapvpwrvgnd_1
XANTENNA__307__B1 _304_/X vssd1 vccd1 vccd1 vssd1 X2_sky130_fd_sc_hd__diode_2
XFILLER_2_139 vccd1 vssd1 vccd1 vssd1 X2_sky130_fd_sc_hd__fill_1
XFILLER_78_419 vccd1 vssd1 vccd1 vssd1 X2_sky130_fd_sc_hd__fill_1
XFILLER_59_611 vccd1 vssd1 vccd1 vssd1 X2_sky130_fd_sc_hd__fill_1
XFILLER_58_121 vssd1 vccd1 vssd1 vccd1 X2_sky130_ef_sc_hd__decap_40_12
XFILLER_100_251 vccd1 vssd1 vccd1 vssd1 X2_sky130_fd_sc_hd__fill_1
XFILLER_58_165 vssd1 vccd1 vssd1 vccd1 X2_sky130_ef_sc_hd__decap_40_12
XTAP_TAPCELL_ROW_29_536 vccd1 vssd1 X2_sky130_fd_sc_hd__tapvpwrvgnd_1
XANTENNA_fanout64_A _525_/A vssd1 vccd1 vccd1 vssd1 X2_sky130_fd_sc_hd__diode_2
XFILLER_73_113 vssd1 vccd1 vssd1 vccd1 X2_sky130_ef_sc_hd__decap_40_12
XTAP_TAPCELL_ROW_57_845 vccd1 vssd1 X2_sky130_fd_sc_hd__tapvpwrvgnd_1
XFILLER_27_541 vssd1 vccd1 vssd1 vccd1 X2_sky130_ef_sc_hd__decap_40_12
XFILLER_39_390 vssd1 vccd1 vccd1 vssd1 X2_sky130_fd_sc_hd__fill_2
XFILLER_64_23 vssd1 vccd1 vccd1 vssd1 X2_sky130_fd_sc_hd__fill_4
XFILLER_27_585 vssd1 vccd1 vssd1 vccd1 X2_sky130_ef_sc_hd__decap_40_12
XFILLER_54_360 vssd1 vccd1 vccd1 vssd1 X2_sky130_fd_sc_hd__fill_4
XFILLER_42_533 vssd1 vccd1 vccd1 vssd1 X2_sky130_fd_sc_hd__fill_4
X_322_ vccd1 vssd1 vssd1 vccd1 _321_/X _317_/B hold34/X _319_/X _322_/X X2_sky130_fd_sc_hd__o22a_1
Xfanout61 _529_/A _521_/A vccd1 vssd1 vssd1 vccd1 X2_sky130_fd_sc_hd__clkbuf_8
XFILLER_6_401 vssd1 vccd1 vssd1 vccd1 X2_sky130_ef_sc_hd__decap_40_12
XFILLER_80_77 vssd1 vccd1 vccd1 vssd1 X2_sky130_fd_sc_hd__fill_4
XFILLER_6_445 vssd1 vccd1 vssd1 vccd1 X2_sky130_ef_sc_hd__decap_40_12
XFILLER_13_93 vssd1 vccd1 vssd1 vccd1 X2_sky130_ef_sc_hd__decap_40_12
XFILLER_6_489 vssd1 vccd1 vssd1 vccd1 X2_sky130_ef_sc_hd__decap_40_12
XFILLER_1_161 vssd1 vccd1 vccd1 vssd1 X2_sky130_fd_sc_hd__fill_4
XFILLER_96_249 vssd1 vccd1 vccd1 vssd1 X2_sky130_fd_sc_hd__fill_2
XFILLER_77_441 vssd1 vccd1 vccd1 vssd1 X2_sky130_fd_sc_hd__fill_4
XFILLER_49_165 vssd1 vccd1 vccd1 vssd1 X2_sky130_fd_sc_hd__fill_2
XFILLER_92_433 vssd1 vccd1 vssd1 vccd1 X2_sky130_ef_sc_hd__decap_40_12
XFILLER_77_485 vssd1 vccd1 vssd1 vccd1 X2_sky130_ef_sc_hd__decap_40_12
XFILLER_92_477 vssd1 vccd1 vssd1 vccd1 X2_sky130_ef_sc_hd__decap_40_12
XFILLER_18_585 vssd1 vccd1 vccd1 vssd1 X2_sky130_fd_sc_hd__fill_2
XFILLER_52_319 vccd1 vssd1 vccd1 vssd1 X2_sky130_fd_sc_hd__fill_1
XTAP_TAPCELL_ROW_82_1125 vccd1 vssd1 X2_sky130_fd_sc_hd__tapvpwrvgnd_1
XFILLER_45_393 vssd1 vccd1 vssd1 vccd1 X2_sky130_ef_sc_hd__decap_40_12
XFILLER_33_588 vssd1 vccd1 vccd1 vssd1 X2_sky130_fd_sc_hd__fill_2
XANTENNA__473__A _473_/A vssd1 vccd1 vccd1 vssd1 X2_sky130_fd_sc_hd__diode_2
XFILLER_9_261 vssd1 vccd1 vssd1 vccd1 X2_sky130_ef_sc_hd__decap_40_12
XFILLER_20_249 vssd1 vccd1 vccd1 vssd1 X2_sky130_fd_sc_hd__fill_2
XTAP_TAPCELL_ROW_93_1243 vccd1 vssd1 X2_sky130_fd_sc_hd__tapvpwrvgnd_1
XFILLER_87_205 vssd1 vccd1 vssd1 vccd1 X2_sky130_ef_sc_hd__decap_40_12
XANTENNA__535__CLK _553_/CLK vssd1 vccd1 vccd1 vssd1 X2_sky130_fd_sc_hd__diode_2
XFILLER_87_249 vssd1 vccd1 vssd1 vccd1 X2_sky130_ef_sc_hd__decap_40_12
XFILLER_28_305 vssd1 vccd1 vccd1 vssd1 X2_sky130_fd_sc_hd__fill_2
XFILLER_18_27 vccd1 vssd1 vccd1 vssd1 X2_sky130_fd_sc_hd__fill_1
XFILLER_95_293 vssd1 vccd1 vccd1 vssd1 X2_sky130_fd_sc_hd__fill_2
XFILLER_55_113 vssd1 vccd1 vssd1 vccd1 X2_sky130_ef_sc_hd__decap_40_12
XFILLER_71_617 vssd1 vccd1 vccd1 vssd1 X2_sky130_fd_sc_hd__fill_2
XTAP_TAPCELL_ROW_26_506 vccd1 vssd1 X2_sky130_fd_sc_hd__tapvpwrvgnd_1
XTAP_TAPCELL_ROW_54_815 vccd1 vssd1 X2_sky130_fd_sc_hd__tapvpwrvgnd_1
XFILLER_24_533 vssd1 vccd1 vssd1 vccd1 X2_sky130_ef_sc_hd__decap_40_12
XFILLER_34_15 vssd1 vccd1 vssd1 vccd1 X2_sky130_ef_sc_hd__decap_40_12
XFILLER_11_205 vssd1 vccd1 vssd1 vccd1 X2_sky130_ef_sc_hd__decap_40_12
XTAP_TAPCELL_ROW_34_594 vccd1 vssd1 X2_sky130_fd_sc_hd__tapvpwrvgnd_1
XFILLER_51_385 vssd1 vccd1 vccd1 vssd1 X2_sky130_fd_sc_hd__fill_4
XFILLER_11_249 vssd1 vccd1 vssd1 vccd1 X2_sky130_ef_sc_hd__decap_40_12
Xclkload3 vccd1 vssd1 vccd1 vssd1 clkload3/Y _599_/CLK X2_sky130_fd_sc_hd__inv_6
XFILLER_78_249 vssd1 vccd1 vccd1 vssd1 X2_sky130_fd_sc_hd__fill_2
XTAP_TAPCELL_ROW_6_286 vccd1 vssd1 X2_sky130_fd_sc_hd__tapvpwrvgnd_1
XFILLER_19_305 vssd1 vccd1 vssd1 vccd1 X2_sky130_ef_sc_hd__decap_40_12
XFILLER_59_441 vssd1 vccd1 vccd1 vssd1 X2_sky130_fd_sc_hd__fill_4
XFILLER_75_55 vccd1 vssd1 vccd1 vssd1 X2_sky130_fd_sc_hd__fill_1
XFILLER_74_433 vssd1 vccd1 vssd1 vccd1 X2_sky130_ef_sc_hd__decap_40_12
XFILLER_59_485 vssd1 vccd1 vssd1 vccd1 X2_sky130_ef_sc_hd__decap_40_12
XFILLER_19_349 vssd1 vccd1 vssd1 vccd1 X2_sky130_ef_sc_hd__decap_40_12
XFILLER_74_477 vssd1 vccd1 vssd1 vccd1 X2_sky130_ef_sc_hd__decap_40_12
XFILLER_61_105 vssd1 vccd1 vccd1 vssd1 X2_sky130_fd_sc_hd__fill_4
XFILLER_27_393 vssd1 vccd1 vssd1 vccd1 X2_sky130_ef_sc_hd__decap_40_12
XFILLER_61_149 vssd1 vccd1 vssd1 vccd1 X2_sky130_ef_sc_hd__decap_40_12
XFILLER_42_363 vccd1 vssd1 vccd1 vssd1 X2_sky130_fd_sc_hd__fill_1
XFILLER_42_341 vccd1 vssd1 vccd1 vssd1 X2_sky130_fd_sc_hd__fill_1
XFILLER_30_525 vssd1 vccd1 vccd1 vssd1 X2_sky130_fd_sc_hd__fill_4
X_305_ vccd1 vssd1 vccd1 vssd1 _304_/X _572_/Q _303_/X _305_/X hold9/X X2_sky130_fd_sc_hd__a22o_1
XFILLER_24_81 vssd1 vccd1 vccd1 vssd1 X2_sky130_fd_sc_hd__fill_2
XFILLER_30_569 vssd1 vccd1 vssd1 vccd1 X2_sky130_ef_sc_hd__decap_40_12
XFILLER_6_253 vssd1 vccd1 vssd1 vccd1 X2_sky130_ef_sc_hd__decap_40_12
XFILLER_97_503 vccd1 vssd1 vccd1 vssd1 X2_sky130_fd_sc_hd__fill_1
XFILLER_69_205 vssd1 vccd1 vssd1 vccd1 X2_sky130_ef_sc_hd__decap_40_12
XFILLER_69_249 vssd1 vccd1 vssd1 vccd1 X2_sky130_ef_sc_hd__decap_40_12
XFILLER_38_614 vssd1 vccd1 vccd1 vssd1 X2_sky130_fd_sc_hd__fill_2
XANTENNA__468__A _473_/A vssd1 vccd1 vccd1 vssd1 X2_sky130_fd_sc_hd__diode_2
XFILLER_37_113 vssd1 vccd1 vssd1 vccd1 X2_sky130_ef_sc_hd__decap_40_12
XFILLER_77_293 vssd1 vccd1 vssd1 vccd1 X2_sky130_ef_sc_hd__decap_40_12
XFILLER_92_285 vssd1 vccd1 vssd1 vccd1 X2_sky130_ef_sc_hd__decap_40_12
XFILLER_53_617 vssd1 vccd1 vccd1 vssd1 X2_sky130_fd_sc_hd__fill_4
XFILLER_21_503 vccd1 vssd1 vccd1 vssd1 X2_sky130_fd_sc_hd__fill_1
XFILLER_80_469 vssd1 vccd1 vccd1 vssd1 X2_sky130_fd_sc_hd__fill_4
XFILLER_33_396 vssd1 vccd1 vccd1 vssd1 X2_sky130_fd_sc_hd__fill_2
XFILLER_60_193 vssd1 vccd1 vccd1 vssd1 X2_sky130_fd_sc_hd__fill_2
XTAP_TAPCELL_ROW_31_564 vccd1 vssd1 X2_sky130_fd_sc_hd__tapvpwrvgnd_1
XFILLER_88_525 vssd1 vccd1 vccd1 vssd1 X2_sky130_fd_sc_hd__fill_4
XFILLER_29_15 vssd1 vccd1 vssd1 vccd1 X2_sky130_ef_sc_hd__decap_40_12
XFILLER_88_569 vssd1 vccd1 vssd1 vccd1 X2_sky130_ef_sc_hd__decap_40_12
Xhold26 hold26/X _568_/Q vccd1 vssd1 vssd1 vccd1 X2_sky130_fd_sc_hd__dlygate4sd3_1
Xhold37 _555_/D _540_/Q vccd1 vssd1 vssd1 vccd1 X2_sky130_fd_sc_hd__dlygate4sd3_1
Xhold15 hold15/X _557_/Q vccd1 vssd1 vssd1 vccd1 X2_sky130_fd_sc_hd__dlygate4sd3_1
Xhold59 hold59/X _560_/Q vccd1 vssd1 vssd1 vccd1 X2_sky130_fd_sc_hd__dlygate4sd3_1
Xhold48 hold48/X _588_/Q vccd1 vssd1 vssd1 vccd1 X2_sky130_fd_sc_hd__dlygate4sd3_1
XTAP_TAPCELL_ROW_3_256 vccd1 vssd1 X2_sky130_fd_sc_hd__tapvpwrvgnd_1
XTAP_TAPCELL_ROW_39_653 vccd1 vssd1 X2_sky130_fd_sc_hd__tapvpwrvgnd_1
XFILLER_68_293 vssd1 vccd1 vssd1 vccd1 X2_sky130_ef_sc_hd__decap_40_12
XTAP_TAPCELL_ROW_67_962 vccd1 vssd1 X2_sky130_fd_sc_hd__tapvpwrvgnd_1
XFILLER_56_433 vssd1 vccd1 vssd1 vccd1 X2_sky130_ef_sc_hd__decap_40_12
XFILLER_56_477 vssd1 vccd1 vssd1 vccd1 X2_sky130_ef_sc_hd__decap_40_12
XFILLER_43_105 vssd1 vccd1 vccd1 vssd1 X2_sky130_fd_sc_hd__fill_4
XFILLER_71_447 vccd1 vssd1 vccd1 vssd1 X2_sky130_fd_sc_hd__fill_1
XFILLER_45_69 vssd1 vccd1 vssd1 vccd1 X2_sky130_ef_sc_hd__decap_40_12
XFILLER_43_149 vssd1 vccd1 vssd1 vccd1 X2_sky130_ef_sc_hd__decap_40_12
XFILLER_24_363 vccd1 vssd1 vccd1 vssd1 X2_sky130_fd_sc_hd__fill_1
XFILLER_12_525 vssd1 vccd1 vccd1 vssd1 X2_sky130_fd_sc_hd__fill_4
XFILLER_101_53 vssd1 vccd1 vccd1 vssd1 X2_sky130_fd_sc_hd__fill_2
XFILLER_12_569 vssd1 vccd1 vssd1 vccd1 X2_sky130_ef_sc_hd__decap_40_12
XFILLER_101_97 vssd1 vccd1 vssd1 vccd1 X2_sky130_ef_sc_hd__decap_40_12
XFILLER_61_57 vssd1 vccd1 vssd1 vccd1 X2_sky130_ef_sc_hd__decap_40_12
XFILLER_51_193 vssd1 vccd1 vccd1 vssd1 X2_sky130_fd_sc_hd__fill_8
XFILLER_8_529 vssd1 vccd1 vccd1 vssd1 X2_sky130_fd_sc_hd__fill_2
XFILLER_3_223 vccd1 vssd1 vccd1 vssd1 X2_sky130_fd_sc_hd__fill_1
XFILLER_79_503 vccd1 vssd1 vccd1 vssd1 X2_sky130_fd_sc_hd__fill_1
XFILLER_10_83 vccd1 vssd1 vccd1 vssd1 X2_sky130_fd_sc_hd__fill_1
XFILLER_86_65 vssd1 vccd1 vssd1 vccd1 X2_sky130_ef_sc_hd__decap_40_12
XFILLER_19_113 vssd1 vccd1 vssd1 vccd1 X2_sky130_ef_sc_hd__decap_40_12
XFILLER_19_81 vssd1 vccd1 vssd1 vccd1 X2_sky130_ef_sc_hd__decap_40_12
XFILLER_59_293 vssd1 vccd1 vssd1 vccd1 X2_sky130_ef_sc_hd__decap_40_12
XFILLER_35_617 vccd1 vssd1 vccd1 vssd1 X2_sky130_fd_sc_hd__fill_1
XFILLER_62_469 vssd1 vccd1 vccd1 vssd1 X2_sky130_fd_sc_hd__fill_4
XFILLER_50_609 vssd1 vccd1 vccd1 vssd1 X2_sky130_fd_sc_hd__fill_2
XFILLER_15_385 vssd1 vccd1 vccd1 vssd1 X2_sky130_fd_sc_hd__fill_4
XFILLER_30_322 vssd1 vccd1 vccd1 vssd1 X2_sky130_fd_sc_hd__fill_2
XFILLER_42_193 vssd1 vccd1 vccd1 vssd1 X2_sky130_fd_sc_hd__fill_2
XFILLER_30_377 vssd1 vccd1 vssd1 vccd1 X2_sky130_ef_sc_hd__decap_40_12
XFILLER_7_573 vssd1 vccd1 vssd1 vccd1 X2_sky130_ef_sc_hd__decap_40_12
XTAP_TAPCELL_ROW_77_1068 vccd1 vssd1 X2_sky130_fd_sc_hd__tapvpwrvgnd_1
XTAP_TAPCELL_ROW_90_1213 vccd1 vssd1 X2_sky130_fd_sc_hd__tapvpwrvgnd_1
XPHY_EDGE_ROW_29_Left_131 vccd1 vssd1 vccd1 vssd1 X2_sky130_fd_sc_hd__decap_3
XFILLER_97_355 vssd1 vccd1 vccd1 vssd1 X2_sky130_fd_sc_hd__fill_4
XFILLER_97_377 vssd1 vccd1 vccd1 vssd1 X2_sky130_fd_sc_hd__fill_2
XFILLER_85_517 vssd1 vccd1 vssd1 vccd1 X2_sky130_ef_sc_hd__decap_40_12
XTAP_TAPCELL_ROW_0_204 vccd1 vssd1 X2_sky130_fd_sc_hd__tapvpwrvgnd_1
XTAP_TAPCELL_ROW_0_215 vccd1 vssd1 X2_sky130_fd_sc_hd__tapvpwrvgnd_1
XFILLER_25_105 vssd1 vccd1 vccd1 vssd1 X2_sky130_fd_sc_hd__fill_4
XFILLER_38_477 vccd1 vssd1 vccd1 vssd1 X2_sky130_fd_sc_hd__fill_1
XFILLER_93_561 vssd1 vccd1 vssd1 vccd1 X2_sky130_ef_sc_hd__decap_40_12
XFILLER_25_149 vssd1 vccd1 vssd1 vccd1 X2_sky130_ef_sc_hd__decap_40_12
XTAP_TAPCELL_ROW_36_612 vccd1 vssd1 X2_sky130_fd_sc_hd__tapvpwrvgnd_1
XTAP_TAPCELL_ROW_88_1186 vccd1 vssd1 X2_sky130_fd_sc_hd__tapvpwrvgnd_1
XFILLER_80_233 vssd1 vccd1 vssd1 vccd1 X2_sky130_ef_sc_hd__decap_40_12
XTAP_TAPCELL_ROW_64_921 vccd1 vssd1 X2_sky130_fd_sc_hd__tapvpwrvgnd_1
XFILLER_15_39 vssd1 vccd1 vssd1 vccd1 X2_sky130_ef_sc_hd__decap_40_12
XPHY_EDGE_ROW_38_Left_140 vccd1 vssd1 vccd1 vssd1 X2_sky130_fd_sc_hd__decap_3
XFILLER_80_277 vssd1 vccd1 vssd1 vccd1 X2_sky130_ef_sc_hd__decap_40_12
XTAP_TAPCELL_ROW_16_391 vccd1 vssd1 X2_sky130_fd_sc_hd__tapvpwrvgnd_1
XFILLER_21_333 vssd1 vccd1 vccd1 vssd1 X2_sky130_fd_sc_hd__fill_2
XFILLER_33_193 vssd1 vccd1 vccd1 vssd1 X2_sky130_fd_sc_hd__fill_8
XFILLER_31_27 vssd1 vccd1 vssd1 vccd1 X2_sky130_ef_sc_hd__decap_40_12
XTAP_TAPCELL_ROW_8_304 vccd1 vssd1 X2_sky130_fd_sc_hd__tapvpwrvgnd_1
Xoutput49 vccd1 vssd1 wbs_dat_o[15] _572_/Q vccd1 vssd1 X2_sky130_fd_sc_hd__buf_2
XFILLER_0_237 vssd1 vccd1 vssd1 vccd1 X2_sky130_ef_sc_hd__decap_40_12
XFILLER_88_333 vssd1 vccd1 vssd1 vccd1 X2_sky130_ef_sc_hd__decap_40_12
XFILLER_17_617 vssd1 vccd1 vccd1 vssd1 X2_sky130_fd_sc_hd__fill_8
X_570_ vssd1 vccd1 vccd1 vssd1 _606_/CLK hold8/X _490_/Y _570_/Q X2_sky130_fd_sc_hd__dfrtp_1
XFILLER_44_414 vssd1 vccd1 vccd1 vssd1 X2_sky130_fd_sc_hd__fill_2
XFILLER_71_277 vssd1 vccd1 vccd1 vssd1 X2_sky130_fd_sc_hd__fill_2
XFILLER_12_333 vssd1 vccd1 vssd1 vccd1 X2_sky130_ef_sc_hd__decap_40_12
XFILLER_24_193 vssd1 vccd1 vccd1 vssd1 X2_sky130_fd_sc_hd__fill_2
XFILLER_12_377 vssd1 vccd1 vssd1 vccd1 X2_sky130_ef_sc_hd__decap_40_12
XFILLER_99_609 vssd1 vccd1 vccd1 vssd1 X2_sky130_fd_sc_hd__fill_4
XFILLER_21_93 vssd1 vccd1 vssd1 vccd1 X2_sky130_ef_sc_hd__decap_40_12
XFILLER_4_587 vccd1 vssd1 vccd1 vssd1 X2_sky130_fd_sc_hd__fill_1
XFILLER_79_333 vssd1 vccd1 vccd1 vssd1 X2_sky130_fd_sc_hd__fill_2
XFILLER_67_517 vssd1 vccd1 vssd1 vccd1 X2_sky130_ef_sc_hd__decap_40_12
XFILLER_75_561 vssd1 vccd1 vssd1 vccd1 X2_sky130_ef_sc_hd__decap_40_12
XFILLER_90_531 vccd1 vssd1 vccd1 vssd1 X2_sky130_fd_sc_hd__fill_1
XFILLER_23_609 vssd1 vccd1 vccd1 vssd1 X2_sky130_fd_sc_hd__fill_4
XFILLER_62_277 vssd1 vccd1 vssd1 vccd1 X2_sky130_ef_sc_hd__decap_40_12
XFILLER_15_193 vssd1 vccd1 vssd1 vccd1 X2_sky130_ef_sc_hd__decap_40_12
XFILLER_30_141 vssd1 vccd1 vssd1 vccd1 X2_sky130_ef_sc_hd__decap_40_12
XFILLER_87_3 vssd1 vccd1 vssd1 vccd1 X2_sky130_ef_sc_hd__decap_40_12
XTAP_TAPCELL_ROW_13_361 vccd1 vssd1 X2_sky130_fd_sc_hd__tapvpwrvgnd_1
XANTENNA__481__A _517_/A vssd1 vccd1 vccd1 vssd1 X2_sky130_fd_sc_hd__diode_2
XTAP_TAPCELL_ROW_41_670 vccd1 vssd1 X2_sky130_fd_sc_hd__tapvpwrvgnd_1
XFILLER_7_51 vssd1 vccd1 vccd1 vssd1 X2_sky130_fd_sc_hd__fill_4
XPHY_EDGE_ROW_15_Right_15 vccd1 vssd1 vccd1 vssd1 X2_sky130_fd_sc_hd__decap_3
XFILLER_26_27 vccd1 vssd1 vccd1 vssd1 X2_sky130_fd_sc_hd__fill_1
XPHY_EDGE_ROW_24_Right_24 vccd1 vssd1 vccd1 vssd1 X2_sky130_fd_sc_hd__decap_3
XFILLER_26_469 vssd1 vccd1 vccd1 vssd1 X2_sky130_fd_sc_hd__fill_4
XFILLER_81_553 vssd1 vccd1 vccd1 vssd1 X2_sky130_fd_sc_hd__fill_4
XFILLER_81_597 vssd1 vccd1 vssd1 vccd1 X2_sky130_ef_sc_hd__decap_40_12
XFILLER_41_428 vssd1 vccd1 vccd1 vssd1 X2_sky130_fd_sc_hd__fill_8
XFILLER_41_417 vssd1 vccd1 vccd1 vssd1 X2_sky130_fd_sc_hd__fill_8
XFILLER_5_329 vssd1 vccd1 vccd1 vssd1 X2_sky130_fd_sc_hd__fill_4
XANTENNA__541__D _541_/D vssd1 vccd1 vccd1 vssd1 X2_sky130_fd_sc_hd__diode_2
XPHY_EDGE_ROW_33_Right_33 vccd1 vssd1 vccd1 vssd1 X2_sky130_fd_sc_hd__decap_3
XFILLER_1_557 vssd1 vccd1 vccd1 vssd1 X2_sky130_fd_sc_hd__fill_2
XFILLER_88_141 vssd1 vccd1 vssd1 vccd1 X2_sky130_ef_sc_hd__decap_40_12
XFILLER_67_23 vssd1 vccd1 vssd1 vccd1 X2_sky130_ef_sc_hd__decap_40_12
XFILLER_57_561 vssd1 vccd1 vssd1 vccd1 X2_sky130_ef_sc_hd__decap_40_12
XFILLER_72_531 vccd1 vssd1 vccd1 vssd1 X2_sky130_fd_sc_hd__fill_1
XFILLER_57_583 vccd1 vssd1 vccd1 vssd1 X2_sky130_fd_sc_hd__fill_1
XPHY_EDGE_ROW_42_Right_42 vccd1 vssd1 vccd1 vssd1 X2_sky130_fd_sc_hd__decap_3
XFILLER_17_447 vccd1 vssd1 vccd1 vssd1 X2_sky130_fd_sc_hd__fill_1
XFILLER_83_55 vccd1 vssd1 vccd1 vssd1 X2_sky130_fd_sc_hd__fill_1
X_553_ vssd1 vccd1 vccd1 vssd1 _553_/CLK _553_/D _473_/Y _553_/Q X2_sky130_fd_sc_hd__dfrtp_1
XFILLER_44_277 vssd1 vccd1 vssd1 vccd1 X2_sky130_ef_sc_hd__decap_40_12
X_484_ vccd1 vssd1 vccd1 vssd1 _484_/Y _517_/A X2_sky130_fd_sc_hd__inv_2
XFILLER_9_613 vssd1 vccd1 vccd1 vssd1 X2_sky130_fd_sc_hd__fill_2
XFILLER_12_141 vssd1 vccd1 vssd1 vccd1 X2_sky130_ef_sc_hd__decap_40_12
XTAP_TAPCELL_ROW_10_331 vccd1 vssd1 X2_sky130_fd_sc_hd__tapvpwrvgnd_1
XFILLER_32_81 vssd1 vccd1 vccd1 vssd1 X2_sky130_fd_sc_hd__fill_2
XPHY_EDGE_ROW_51_Right_51 vccd1 vssd1 vccd1 vssd1 X2_sky130_fd_sc_hd__decap_3
XFILLER_8_189 vssd1 vccd1 vccd1 vssd1 X2_sky130_fd_sc_hd__fill_4
XFILLER_99_439 vssd1 vccd1 vccd1 vssd1 X2_sky130_fd_sc_hd__fill_8
XTAP_TAPCELL_ROW_74_1038 vccd1 vssd1 X2_sky130_fd_sc_hd__tapvpwrvgnd_1
XFILLER_67_314 vssd1 vccd1 vssd1 vccd1 X2_sky130_ef_sc_hd__decap_40_12
XFILLER_94_133 vssd1 vccd1 vccd1 vssd1 X2_sky130_fd_sc_hd__fill_4
XFILLER_94_177 vssd1 vccd1 vssd1 vccd1 X2_sky130_ef_sc_hd__decap_40_12
XPHY_EDGE_ROW_60_Right_60 vccd1 vssd1 vccd1 vssd1 X2_sky130_fd_sc_hd__decap_3
XFILLER_48_561 vssd1 vccd1 vccd1 vssd1 X2_sky130_fd_sc_hd__fill_2
XFILLER_48_550 vssd1 vccd1 vccd1 vssd1 X2_sky130_fd_sc_hd__fill_2
XFILLER_75_391 vccd1 vssd1 vccd1 vssd1 X2_sky130_fd_sc_hd__fill_1
XANTENNA__476__A _521_/A vssd1 vccd1 vccd1 vssd1 X2_sky130_fd_sc_hd__diode_2
XTAP_TAPCELL_ROW_18_420 vccd1 vssd1 X2_sky130_fd_sc_hd__tapvpwrvgnd_1
XFILLER_90_350 vssd1 vccd1 vssd1 vccd1 X2_sky130_ef_sc_hd__decap_40_12
XTAP_TAPCELL_ROW_85_1156 vccd1 vssd1 X2_sky130_fd_sc_hd__tapvpwrvgnd_1
XFILLER_63_553 vssd1 vccd1 vccd1 vssd1 X2_sky130_fd_sc_hd__fill_4
XFILLER_23_417 vssd1 vccd1 vssd1 vccd1 X2_sky130_ef_sc_hd__decap_40_12
XFILLER_35_266 vssd1 vccd1 vssd1 vccd1 X2_sky130_ef_sc_hd__decap_40_12
XFILLER_63_597 vssd1 vccd1 vccd1 vssd1 X2_sky130_fd_sc_hd__fill_2
XFILLER_63_575 vccd1 vssd1 vccd1 vssd1 X2_sky130_fd_sc_hd__fill_1
XFILLER_31_461 vssd1 vccd1 vssd1 vccd1 X2_sky130_ef_sc_hd__decap_40_12
XFILLER_12_29 vssd1 vccd1 vssd1 vccd1 X2_sky130_ef_sc_hd__decap_40_12
XTAP_TAPCELL_ROW_96_1274 vccd1 vssd1 X2_sky130_fd_sc_hd__tapvpwrvgnd_1
XFILLER_86_601 vssd1 vccd1 vssd1 vccd1 X2_sky130_ef_sc_hd__decap_40_12
XFILLER_58_314 vssd1 vccd1 vssd1 vccd1 X2_sky130_ef_sc_hd__decap_40_12
XFILLER_37_15 vssd1 vccd1 vssd1 vccd1 X2_sky130_ef_sc_hd__decap_40_12
XFILLER_100_433 vssd1 vccd1 vssd1 vccd1 X2_sky130_ef_sc_hd__decap_40_12
XFILLER_85_111 vccd1 vssd1 vccd1 vssd1 X2_sky130_fd_sc_hd__fill_1
XFILLER_39_561 vssd1 vccd1 vssd1 vccd1 X2_sky130_ef_sc_hd__decap_40_12
XFILLER_100_477 vssd1 vccd1 vssd1 vccd1 X2_sky130_ef_sc_hd__decap_40_12
XFILLER_73_317 vssd1 vccd1 vssd1 vccd1 X2_sky130_ef_sc_hd__decap_40_12
XFILLER_26_233 vssd1 vccd1 vssd1 vccd1 X2_sky130_ef_sc_hd__decap_40_12
XFILLER_54_564 vssd1 vccd1 vccd1 vssd1 X2_sky130_fd_sc_hd__fill_2
XFILLER_14_417 vssd1 vccd1 vccd1 vssd1 X2_sky130_fd_sc_hd__fill_2
XFILLER_26_277 vssd1 vccd1 vssd1 vccd1 X2_sky130_ef_sc_hd__decap_40_12
XFILLER_41_203 vssd1 vccd1 vccd1 vssd1 X2_sky130_fd_sc_hd__fill_2
XFILLER_81_361 vssd1 vccd1 vssd1 vccd1 X2_sky130_ef_sc_hd__decap_40_12
XFILLER_54_586 vssd1 vccd1 vccd1 vssd1 X2_sky130_fd_sc_hd__fill_2
XFILLER_41_225 vssd1 vccd1 vccd1 vssd1 X2_sky130_fd_sc_hd__fill_8
XFILLER_53_69 vssd1 vccd1 vssd1 vccd1 X2_sky130_ef_sc_hd__decap_40_12
XFILLER_10_601 vssd1 vccd1 vssd1 vccd1 X2_sky130_ef_sc_hd__decap_40_12
XTAP_TAPCELL_ROW_52_787 vccd1 vssd1 X2_sky130_fd_sc_hd__tapvpwrvgnd_1
XTAP_TAPCELL_ROW_24_489 vccd1 vssd1 X2_sky130_fd_sc_hd__tapvpwrvgnd_1
XFILLER_5_137 vssd1 vccd1 vssd1 vccd1 X2_sky130_ef_sc_hd__decap_40_12
XFILLER_1_321 vssd1 vccd1 vccd1 vssd1 X2_sky130_fd_sc_hd__fill_2
XFILLER_89_461 vssd1 vccd1 vssd1 vccd1 X2_sky130_ef_sc_hd__decap_40_12
XFILLER_78_77 vssd1 vccd1 vccd1 vssd1 X2_sky130_fd_sc_hd__fill_4
XFILLER_76_133 vssd1 vccd1 vccd1 vssd1 X2_sky130_fd_sc_hd__fill_4
XFILLER_49_347 vccd1 vssd1 vccd1 vssd1 X2_sky130_fd_sc_hd__fill_1
XFILLER_91_125 vssd1 vccd1 vssd1 vccd1 X2_sky130_ef_sc_hd__decap_40_12
XFILLER_94_65 vssd1 vccd1 vssd1 vccd1 X2_sky130_ef_sc_hd__decap_40_12
XFILLER_76_177 vssd1 vccd1 vssd1 vccd1 X2_sky130_ef_sc_hd__decap_40_12
XFILLER_27_81 vssd1 vccd1 vssd1 vccd1 X2_sky130_ef_sc_hd__decap_40_12
XFILLER_91_169 vssd1 vccd1 vssd1 vccd1 X2_sky130_ef_sc_hd__decap_40_12
X_605_ vssd1 vccd1 vccd1 vssd1 _606_/CLK _605_/D _525_/Y hold9/A X2_sky130_fd_sc_hd__dfrtp_1
XFILLER_57_391 vccd1 vssd1 vccd1 vssd1 X2_sky130_fd_sc_hd__fill_1
XFILLER_17_277 vssd1 vccd1 vccd1 vssd1 X2_sky130_fd_sc_hd__fill_2
X_536_ vssd1 vccd1 vccd1 vssd1 _553_/CLK _536_/D _456_/Y _536_/Q X2_sky130_fd_sc_hd__dfrtp_4
XFILLER_72_361 vssd1 vccd1 vccd1 vssd1 X2_sky130_fd_sc_hd__fill_2
XFILLER_60_501 vssd1 vccd1 vssd1 vccd1 X2_sky130_ef_sc_hd__decap_40_12
XFILLER_32_225 vssd1 vccd1 vssd1 vccd1 X2_sky130_ef_sc_hd__decap_40_12
XFILLER_60_545 vssd1 vccd1 vssd1 vccd1 X2_sky130_ef_sc_hd__decap_40_12
XFILLER_13_461 vssd1 vccd1 vssd1 vccd1 X2_sky130_ef_sc_hd__decap_40_12
X_467_ vccd1 vssd1 vccd1 vssd1 _467_/Y _473_/A X2_sky130_fd_sc_hd__inv_2
XFILLER_60_589 vssd1 vccd1 vccd1 vssd1 X2_sky130_fd_sc_hd__fill_8
X_398_ _416_/B _553_/Q _538_/Q vssd1 vccd1 vccd1 vssd1 X2_sky130_fd_sc_hd__and2b_1
XTAP_TAPCELL_ROW_80_1097 vccd1 vssd1 X2_sky130_fd_sc_hd__tapvpwrvgnd_1
XFILLER_99_225 vssd1 vccd1 vssd1 vccd1 X2_sky130_ef_sc_hd__decap_40_12
XFILLER_4_41 vssd1 vccd1 vssd1 vccd1 X2_sky130_ef_sc_hd__decap_40_12
XFILLER_4_85 vssd1 vccd1 vssd1 vccd1 X2_sky130_ef_sc_hd__decap_40_12
XFILLER_67_111 vccd1 vssd1 vccd1 vssd1 X2_sky130_fd_sc_hd__fill_1
XFILLER_83_615 vccd1 vssd1 vccd1 vssd1 X2_sky130_fd_sc_hd__fill_1
XFILLER_95_497 vssd1 vccd1 vccd1 vssd1 X2_sky130_fd_sc_hd__fill_4
XFILLER_70_309 vssd1 vccd1 vssd1 vccd1 X2_sky130_ef_sc_hd__decap_40_12
XFILLER_48_391 vssd1 vccd1 vccd1 vssd1 X2_sky130_fd_sc_hd__fill_2
XFILLER_63_361 vssd1 vccd1 vssd1 vccd1 X2_sky130_ef_sc_hd__decap_40_12
XFILLER_23_225 vssd1 vccd1 vssd1 vccd1 X2_sky130_ef_sc_hd__decap_40_12
XFILLER_23_39 vssd1 vccd1 vssd1 vccd1 X2_sky130_ef_sc_hd__decap_40_12
XTAP_TAPCELL_ROW_98_1303 vccd1 vssd1 X2_sky130_fd_sc_hd__tapvpwrvgnd_1
XTAP_TAPCELL_ROW_21_448 vccd1 vssd1 X2_sky130_fd_sc_hd__tapvpwrvgnd_1
XFILLER_59_623 vssd1 vccd1 vccd1 vssd1 X2_sky130_fd_sc_hd__fill_2
XFILLER_58_133 vssd1 vccd1 vccd1 vssd1 X2_sky130_fd_sc_hd__fill_4
XFILLER_86_475 vccd1 vssd1 vccd1 vssd1 X2_sky130_fd_sc_hd__fill_1
XFILLER_46_306 vssd1 vccd1 vccd1 vssd1 X2_sky130_fd_sc_hd__fill_2
XTAP_TAPCELL_ROW_29_537 vccd1 vssd1 X2_sky130_fd_sc_hd__tapvpwrvgnd_1
XFILLER_73_125 vssd1 vccd1 vssd1 vccd1 X2_sky130_ef_sc_hd__decap_40_12
XFILLER_58_177 vssd1 vccd1 vssd1 vccd1 X2_sky130_ef_sc_hd__decap_40_12
XTAP_TAPCELL_ROW_57_846 vccd1 vssd1 X2_sky130_fd_sc_hd__tapvpwrvgnd_1
XFILLER_27_553 vssd1 vccd1 vccd1 vssd1 X2_sky130_fd_sc_hd__fill_4
XFILLER_100_296 vssd1 vccd1 vccd1 vssd1 X2_sky130_fd_sc_hd__fill_2
XFILLER_61_309 vccd1 vssd1 vccd1 vssd1 X2_sky130_fd_sc_hd__fill_1
XFILLER_73_169 vssd1 vccd1 vssd1 vccd1 X2_sky130_ef_sc_hd__decap_40_12
XFILLER_27_597 vssd1 vccd1 vssd1 vccd1 X2_sky130_ef_sc_hd__decap_40_12
X_321_ vccd1 vssd1 vccd1 vssd1 _320_/X _597_/Q _304_/A _321_/X _589_/Q X2_sky130_fd_sc_hd__a22o_1
XFILLER_42_589 vssd1 vccd1 vssd1 vccd1 X2_sky130_ef_sc_hd__decap_40_12
Xfanout62 vccd1 vssd1 vssd1 vccd1 input13/X _521_/A X2_sky130_fd_sc_hd__buf_8
XFILLER_6_413 vssd1 vccd1 vccd1 vssd1 X2_sky130_fd_sc_hd__fill_4
XFILLER_10_475 vccd1 vssd1 vccd1 vssd1 X2_sky130_fd_sc_hd__fill_1
XFILLER_6_457 vssd1 vccd1 vssd1 vccd1 X2_sky130_ef_sc_hd__decap_40_12
XFILLER_49_111 vccd1 vssd1 vccd1 vssd1 X2_sky130_fd_sc_hd__fill_1
XFILLER_92_401 vssd1 vccd1 vssd1 vccd1 X2_sky130_ef_sc_hd__decap_40_12
XFILLER_77_497 vssd1 vccd1 vccd1 vssd1 X2_sky130_fd_sc_hd__fill_4
XFILLER_18_531 vccd1 vssd1 vccd1 vssd1 X2_sky130_fd_sc_hd__fill_1
XFILLER_92_445 vssd1 vccd1 vssd1 vccd1 X2_sky130_ef_sc_hd__decap_40_12
XFILLER_33_501 vssd1 vccd1 vccd1 vssd1 X2_sky130_fd_sc_hd__fill_2
XFILLER_92_489 vssd1 vccd1 vssd1 vccd1 X2_sky130_ef_sc_hd__decap_40_12
XFILLER_52_309 vssd1 vccd1 vccd1 vssd1 X2_sky130_fd_sc_hd__fill_8
XFILLER_45_361 vssd1 vccd1 vssd1 vccd1 X2_sky130_ef_sc_hd__decap_40_12
XTAP_TAPCELL_ROW_82_1126 vccd1 vssd1 X2_sky130_fd_sc_hd__tapvpwrvgnd_1
XFILLER_33_578 vccd1 vssd1 vccd1 vssd1 X2_sky130_fd_sc_hd__fill_1
X_519_ vccd1 vssd1 vccd1 vssd1 _519_/Y _521_/A X2_sky130_fd_sc_hd__inv_2
XFILLER_9_273 vssd1 vccd1 vccd1 vssd1 X2_sky130_fd_sc_hd__fill_4
XPHY_EDGE_ROW_10_Left_112 vccd1 vssd1 vccd1 vssd1 X2_sky130_fd_sc_hd__decap_3
XTAP_TAPCELL_ROW_93_1244 vccd1 vssd1 X2_sky130_fd_sc_hd__tapvpwrvgnd_1
XFILLER_87_217 vssd1 vccd1 vccd1 vssd1 X2_sky130_fd_sc_hd__fill_4
XFILLER_95_261 vssd1 vccd1 vssd1 vccd1 X2_sky130_ef_sc_hd__decap_40_12
XFILLER_68_475 vccd1 vssd1 vccd1 vssd1 X2_sky130_fd_sc_hd__fill_1
XFILLER_55_125 vssd1 vccd1 vssd1 vccd1 X2_sky130_ef_sc_hd__decap_40_12
XFILLER_83_445 vssd1 vccd1 vccd1 vssd1 X2_sky130_fd_sc_hd__fill_2
XFILLER_24_501 vssd1 vccd1 vssd1 vccd1 X2_sky130_ef_sc_hd__decap_40_12
XTAP_TAPCELL_ROW_26_507 vccd1 vssd1 X2_sky130_fd_sc_hd__tapvpwrvgnd_1
XFILLER_36_361 vssd1 vccd1 vccd1 vssd1 X2_sky130_fd_sc_hd__fill_2
XFILLER_55_169 vssd1 vccd1 vssd1 vccd1 X2_sky130_ef_sc_hd__decap_40_12
XTAP_TAPCELL_ROW_54_816 vccd1 vssd1 X2_sky130_fd_sc_hd__tapvpwrvgnd_1
XFILLER_24_545 vssd1 vccd1 vssd1 vccd1 X2_sky130_ef_sc_hd__decap_40_12
XFILLER_34_27 vccd1 vssd1 vccd1 vssd1 X2_sky130_fd_sc_hd__fill_1
XFILLER_70_139 vccd1 vssd1 vccd1 vssd1 X2_sky130_fd_sc_hd__fill_1
XFILLER_11_217 vssd1 vccd1 vccd1 vssd1 X2_sky130_fd_sc_hd__fill_4
XFILLER_24_589 vssd1 vccd1 vssd1 vccd1 X2_sky130_ef_sc_hd__decap_40_12
XTAP_TAPCELL_ROW_34_595 vccd1 vssd1 X2_sky130_fd_sc_hd__tapvpwrvgnd_1
XFILLER_51_397 vssd1 vccd1 vccd1 vssd1 X2_sky130_fd_sc_hd__fill_2
Xclkload4 clkload4/X _597_/CLK vccd1 vssd1 vssd1 vccd1 X2_sky130_fd_sc_hd__clkbuf_8
XFILLER_50_15 vssd1 vccd1 vssd1 vccd1 X2_sky130_ef_sc_hd__decap_40_12
XFILLER_3_405 vssd1 vccd1 vssd1 vccd1 X2_sky130_ef_sc_hd__decap_40_12
XFILLER_3_449 vssd1 vccd1 vssd1 vccd1 X2_sky130_ef_sc_hd__decap_40_12
XFILLER_59_57 vssd1 vccd1 vssd1 vccd1 X2_sky130_ef_sc_hd__decap_40_12
XTAP_TAPCELL_ROW_6_287 vccd1 vssd1 X2_sky130_fd_sc_hd__tapvpwrvgnd_1
XFILLER_19_317 vssd1 vccd1 vssd1 vccd1 X2_sky130_ef_sc_hd__decap_40_12
XFILLER_101_561 vssd1 vccd1 vssd1 vccd1 X2_sky130_ef_sc_hd__decap_40_12
XFILLER_74_401 vssd1 vccd1 vssd1 vccd1 X2_sky130_ef_sc_hd__decap_40_12
XFILLER_59_497 vssd1 vccd1 vccd1 vssd1 X2_sky130_fd_sc_hd__fill_4
XFILLER_74_445 vssd1 vccd1 vssd1 vccd1 X2_sky130_ef_sc_hd__decap_40_12
XFILLER_15_501 vssd1 vccd1 vccd1 vssd1 X2_sky130_fd_sc_hd__fill_2
XFILLER_27_361 vssd1 vccd1 vssd1 vccd1 X2_sky130_ef_sc_hd__decap_40_12
XFILLER_34_309 vccd1 vssd1 vccd1 vssd1 X2_sky130_fd_sc_hd__fill_1
XFILLER_74_489 vssd1 vccd1 vssd1 vccd1 X2_sky130_ef_sc_hd__decap_40_12
XFILLER_62_618 vssd1 vccd1 vccd1 vssd1 X2_sky130_fd_sc_hd__fill_2
XFILLER_91_55 vccd1 vssd1 vccd1 vssd1 X2_sky130_fd_sc_hd__fill_1
X_304_ vssd1 vccd1 vssd1 vccd1 _304_/A _304_/X _317_/B X2_sky130_fd_sc_hd__and2_4
XFILLER_6_221 vssd1 vccd1 vssd1 vccd1 X2_sky130_ef_sc_hd__decap_40_12
XFILLER_6_265 vssd1 vccd1 vssd1 vccd1 X2_sky130_ef_sc_hd__decap_40_12
XFILLER_40_81 vssd1 vccd1 vccd1 vssd1 X2_sky130_fd_sc_hd__fill_2
XFILLER_69_217 vssd1 vccd1 vccd1 vssd1 X2_sky130_fd_sc_hd__fill_4
XFILLER_97_559 vccd1 vssd1 vccd1 vssd1 X2_sky130_fd_sc_hd__fill_1
XFILLER_84_209 vssd1 vccd1 vssd1 vccd1 X2_sky130_ef_sc_hd__decap_40_12
XFILLER_77_261 vssd1 vccd1 vssd1 vccd1 X2_sky130_ef_sc_hd__decap_40_12
XFILLER_37_125 vssd1 vccd1 vssd1 vccd1 X2_sky130_ef_sc_hd__decap_40_12
XFILLER_65_445 vssd1 vccd1 vccd1 vssd1 X2_sky130_fd_sc_hd__fill_2
XFILLER_18_361 vssd1 vccd1 vccd1 vssd1 X2_sky130_fd_sc_hd__fill_2
XFILLER_37_169 vssd1 vccd1 vccd1 vssd1 X2_sky130_fd_sc_hd__fill_8
XFILLER_92_253 vssd1 vccd1 vssd1 vccd1 X2_sky130_ef_sc_hd__decap_40_12
XFILLER_65_478 vssd1 vccd1 vssd1 vccd1 X2_sky130_ef_sc_hd__decap_40_12
XFILLER_53_607 vssd1 vccd1 vccd1 vssd1 X2_sky130_fd_sc_hd__fill_8
XFILLER_92_297 vssd1 vccd1 vccd1 vssd1 X2_sky130_fd_sc_hd__fill_8
XFILLER_52_139 vccd1 vssd1 vccd1 vssd1 X2_sky130_fd_sc_hd__fill_1
XANTENNA__484__A _517_/A vssd1 vccd1 vccd1 vssd1 X2_sky130_fd_sc_hd__diode_2
XFILLER_21_559 vccd1 vssd1 vccd1 vssd1 X2_sky130_fd_sc_hd__fill_1
XTAP_TAPCELL_ROW_31_565 vccd1 vssd1 X2_sky130_fd_sc_hd__tapvpwrvgnd_1
XFILLER_20_29 vssd1 vccd1 vssd1 vccd1 X2_sky130_ef_sc_hd__decap_40_12
XFILLER_0_408 vssd1 vccd1 vssd1 vccd1 X2_sky130_ef_sc_hd__decap_40_12
XFILLER_29_27 vssd1 vccd1 vssd1 vccd1 X2_sky130_ef_sc_hd__decap_40_12
XPHY_EDGE_ROW_89_Right_89 vccd1 vssd1 vccd1 vssd1 X2_sky130_fd_sc_hd__decap_3
Xhold27 _568_/D _312_/X vccd1 vssd1 vssd1 vccd1 X2_sky130_fd_sc_hd__dlygate4sd3_1
Xhold38 hold38/X _567_/Q vccd1 vssd1 vssd1 vccd1 X2_sky130_fd_sc_hd__dlygate4sd3_1
Xhold16 _557_/D _344_/X vccd1 vssd1 vssd1 vccd1 X2_sky130_fd_sc_hd__dlygate4sd3_1
XFILLER_29_615 vccd1 vssd1 vccd1 vssd1 X2_sky130_fd_sc_hd__fill_1
XFILLER_96_581 vssd1 vccd1 vccd1 vssd1 X2_sky130_fd_sc_hd__fill_4
XFILLER_68_261 vccd1 vssd1 vccd1 vssd1 X2_sky130_fd_sc_hd__fill_1
XFILLER_56_401 vssd1 vccd1 vssd1 vccd1 X2_sky130_ef_sc_hd__decap_40_12
Xhold49 hold49/X _583_/Q vccd1 vssd1 vssd1 vccd1 X2_sky130_fd_sc_hd__dlygate4sd3_1
XTAP_TAPCELL_ROW_3_257 vccd1 vssd1 X2_sky130_fd_sc_hd__tapvpwrvgnd_1
XTAP_TAPCELL_ROW_67_952 vccd1 vssd1 X2_sky130_fd_sc_hd__tapvpwrvgnd_1
XFILLER_56_445 vssd1 vccd1 vssd1 vccd1 X2_sky130_ef_sc_hd__decap_40_12
XFILLER_16_309 vssd1 vccd1 vssd1 vccd1 X2_sky130_ef_sc_hd__decap_40_12
XTAP_TAPCELL_ROW_39_654 vccd1 vssd1 X2_sky130_fd_sc_hd__tapvpwrvgnd_1
XFILLER_56_489 vssd1 vccd1 vssd1 vccd1 X2_sky130_ef_sc_hd__decap_40_12
XFILLER_45_15 vssd1 vccd1 vssd1 vccd1 X2_sky130_ef_sc_hd__decap_40_12
XPHY_EDGE_ROW_98_Right_98 vccd1 vssd1 vccd1 vssd1 X2_sky130_fd_sc_hd__decap_3
XFILLER_51_161 vssd1 vccd1 vccd1 vssd1 X2_sky130_fd_sc_hd__fill_4
XFILLER_61_69 vssd1 vccd1 vssd1 vccd1 X2_sky130_ef_sc_hd__decap_40_12
XFILLER_20_581 vssd1 vccd1 vccd1 vssd1 X2_sky130_fd_sc_hd__fill_4
XFILLER_3_279 vccd1 vssd1 vccd1 vssd1 X2_sky130_fd_sc_hd__fill_1
XFILLER_79_559 vccd1 vssd1 vccd1 vssd1 X2_sky130_fd_sc_hd__fill_1
XANTENNA_input37_A wbs_dat_i[8] vssd1 vccd1 vccd1 vssd1 X2_sky130_fd_sc_hd__diode_2
XFILLER_66_209 vssd1 vccd1 vssd1 vccd1 X2_sky130_ef_sc_hd__decap_40_12
XFILLER_94_529 vssd1 vccd1 vccd1 vssd1 X2_sky130_fd_sc_hd__fill_2
XFILLER_86_77 vssd1 vccd1 vccd1 vssd1 X2_sky130_fd_sc_hd__fill_4
XFILLER_59_261 vssd1 vccd1 vccd1 vssd1 X2_sky130_fd_sc_hd__fill_4
XFILLER_59_272 vssd1 vccd1 vccd1 vssd1 X2_sky130_fd_sc_hd__fill_2
XFILLER_47_412 vssd1 vccd1 vccd1 vssd1 X2_sky130_fd_sc_hd__fill_2
XFILLER_19_125 vssd1 vccd1 vssd1 vccd1 X2_sky130_ef_sc_hd__decap_40_12
XFILLER_101_391 vccd1 vssd1 vccd1 vssd1 X2_sky130_fd_sc_hd__fill_1
XFILLER_19_93 vssd1 vccd1 vssd1 vccd1 X2_sky130_ef_sc_hd__decap_40_12
XFILLER_19_169 vssd1 vccd1 vssd1 vccd1 X2_sky130_ef_sc_hd__decap_40_12
XFILLER_74_253 vssd1 vccd1 vssd1 vccd1 X2_sky130_ef_sc_hd__decap_40_12
XFILLER_34_139 vccd1 vssd1 vccd1 vssd1 X2_sky130_fd_sc_hd__fill_1
XFILLER_35_81 vssd1 vccd1 vssd1 vccd1 X2_sky130_ef_sc_hd__decap_40_12
XFILLER_30_389 vssd1 vccd1 vssd1 vccd1 X2_sky130_ef_sc_hd__decap_40_12
XFILLER_7_541 vssd1 vccd1 vssd1 vccd1 X2_sky130_ef_sc_hd__decap_40_12
XFILLER_7_585 vssd1 vccd1 vssd1 vccd1 X2_sky130_ef_sc_hd__decap_40_12
XTAP_TAPCELL_ROW_77_1069 vccd1 vssd1 X2_sky130_fd_sc_hd__tapvpwrvgnd_1
XTAP_TAPCELL_ROW_90_1214 vccd1 vssd1 X2_sky130_fd_sc_hd__tapvpwrvgnd_1
XFILLER_32_3 vssd1 vccd1 vssd1 vccd1 X2_sky130_ef_sc_hd__decap_40_12
XFILLER_97_367 vssd1 vccd1 vccd1 vssd1 X2_sky130_fd_sc_hd__fill_2
XANTENNA__479__A _527_/A vssd1 vccd1 vccd1 vssd1 X2_sky130_fd_sc_hd__diode_2
XFILLER_85_529 vssd1 vccd1 vssd1 vccd1 X2_sky130_ef_sc_hd__decap_40_12
XFILLER_78_581 vssd1 vccd1 vccd1 vssd1 X2_sky130_fd_sc_hd__fill_4
XTAP_TAPCELL_ROW_0_205 vccd1 vssd1 X2_sky130_fd_sc_hd__tapvpwrvgnd_1
XTAP_TAPCELL_ROW_0_216 vccd1 vssd1 X2_sky130_fd_sc_hd__tapvpwrvgnd_1
XFILLER_38_467 vssd1 vccd1 vccd1 vssd1 X2_sky130_fd_sc_hd__fill_2
XFILLER_93_573 vssd1 vccd1 vssd1 vccd1 X2_sky130_ef_sc_hd__decap_40_12
XTAP_TAPCELL_ROW_36_613 vccd1 vssd1 X2_sky130_fd_sc_hd__tapvpwrvgnd_1
XTAP_TAPCELL_ROW_88_1187 vccd1 vssd1 X2_sky130_fd_sc_hd__tapvpwrvgnd_1
XTAP_TAPCELL_ROW_64_922 vccd1 vssd1 X2_sky130_fd_sc_hd__tapvpwrvgnd_1
XFILLER_80_245 vssd1 vccd1 vccd1 vssd1 X2_sky130_fd_sc_hd__fill_4
XFILLER_33_161 vssd1 vccd1 vccd1 vssd1 X2_sky130_fd_sc_hd__fill_4
XFILLER_40_109 vssd1 vccd1 vssd1 vccd1 X2_sky130_ef_sc_hd__decap_40_12
XFILLER_80_289 vssd1 vccd1 vssd1 vccd1 X2_sky130_ef_sc_hd__decap_40_12
XTAP_TAPCELL_ROW_16_392 vccd1 vssd1 X2_sky130_fd_sc_hd__tapvpwrvgnd_1
XFILLER_21_389 vssd1 vccd1 vccd1 vssd1 X2_sky130_fd_sc_hd__fill_2
XFILLER_31_39 vssd1 vccd1 vssd1 vccd1 X2_sky130_ef_sc_hd__decap_40_12
XTAP_TAPCELL_ROW_8_305 vccd1 vssd1 X2_sky130_fd_sc_hd__tapvpwrvgnd_1
XFILLER_88_301 vssd1 vccd1 vccd1 vssd1 X2_sky130_fd_sc_hd__fill_4
XFILLER_0_249 vssd1 vccd1 vccd1 vssd1 X2_sky130_fd_sc_hd__fill_2
XFILLER_88_345 vssd1 vccd1 vccd1 vssd1 X2_sky130_fd_sc_hd__fill_4
XFILLER_88_356 vssd1 vccd1 vccd1 vssd1 X2_sky130_fd_sc_hd__fill_2
XFILLER_76_529 vssd1 vccd1 vccd1 vssd1 X2_sky130_fd_sc_hd__fill_2
XFILLER_29_445 vssd1 vccd1 vccd1 vssd1 X2_sky130_fd_sc_hd__fill_2
XFILLER_56_253 vssd1 vccd1 vssd1 vccd1 X2_sky130_ef_sc_hd__decap_40_12
XFILLER_16_139 vccd1 vssd1 vccd1 vssd1 X2_sky130_fd_sc_hd__fill_1
XANTENNA__548__CLK _553_/CLK vssd1 vccd1 vccd1 vssd1 X2_sky130_fd_sc_hd__diode_2
XFILLER_71_223 vccd1 vssd1 vccd1 vssd1 X2_sky130_fd_sc_hd__fill_1
XFILLER_12_301 vssd1 vccd1 vccd1 vssd1 X2_sky130_fd_sc_hd__fill_4
XFILLER_31_109 vssd1 vccd1 vccd1 vssd1 X2_sky130_fd_sc_hd__fill_2
XFILLER_12_345 vssd1 vccd1 vssd1 vccd1 X2_sky130_ef_sc_hd__decap_40_12
XFILLER_8_305 vssd1 vccd1 vccd1 vssd1 X2_sky130_fd_sc_hd__fill_2
XFILLER_12_389 vssd1 vccd1 vssd1 vccd1 X2_sky130_ef_sc_hd__decap_40_12
XFILLER_4_533 vssd1 vccd1 vssd1 vccd1 X2_sky130_ef_sc_hd__decap_40_12
XFILLER_98_109 vssd1 vccd1 vssd1 vccd1 X2_sky130_ef_sc_hd__decap_40_12
XFILLER_79_389 vssd1 vccd1 vccd1 vssd1 X2_sky130_fd_sc_hd__fill_2
XFILLER_67_529 vssd1 vccd1 vssd1 vccd1 X2_sky130_ef_sc_hd__decap_40_12
XFILLER_75_573 vssd1 vccd1 vssd1 vccd1 X2_sky130_ef_sc_hd__decap_40_12
XFILLER_35_437 vssd1 vccd1 vccd1 vssd1 X2_sky130_fd_sc_hd__fill_2
XANTENNA_clkload2_A _601_/CLK vssd1 vccd1 vccd1 vssd1 X2_sky130_fd_sc_hd__diode_2
XFILLER_15_161 vssd1 vccd1 vccd1 vssd1 X2_sky130_fd_sc_hd__fill_4
XFILLER_22_109 vssd1 vccd1 vssd1 vccd1 X2_sky130_ef_sc_hd__decap_40_12
XFILLER_90_587 vccd1 vssd1 vccd1 vssd1 X2_sky130_fd_sc_hd__fill_1
XFILLER_62_289 vssd1 vccd1 vssd1 vccd1 X2_sky130_ef_sc_hd__decap_40_12
XFILLER_30_153 vssd1 vccd1 vssd1 vccd1 X2_sky130_ef_sc_hd__decap_40_12
XTAP_TAPCELL_ROW_13_362 vccd1 vssd1 X2_sky130_fd_sc_hd__tapvpwrvgnd_1
XFILLER_30_197 vssd1 vccd1 vssd1 vccd1 X2_sky130_ef_sc_hd__decap_40_12
XTAP_TAPCELL_ROW_41_671 vccd1 vssd1 X2_sky130_fd_sc_hd__tapvpwrvgnd_1
XFILLER_7_393 vssd1 vccd1 vssd1 vccd1 X2_sky130_ef_sc_hd__decap_40_12
XFILLER_89_109 vssd1 vccd1 vccd1 vssd1 X2_sky130_fd_sc_hd__fill_2
XFILLER_58_529 vssd1 vccd1 vccd1 vssd1 X2_sky130_fd_sc_hd__fill_2
XFILLER_85_337 vssd1 vccd1 vssd1 vccd1 X2_sky130_ef_sc_hd__decap_40_12
XFILLER_38_253 vccd1 vssd1 vccd1 vssd1 X2_sky130_fd_sc_hd__fill_1
XTAP_TAPCELL_ROW_49_760 vccd1 vssd1 X2_sky130_fd_sc_hd__tapvpwrvgnd_1
XFILLER_13_109 vssd1 vccd1 vccd1 vssd1 X2_sky130_fd_sc_hd__fill_2
XFILLER_53_267 vssd1 vccd1 vssd1 vccd1 X2_sky130_ef_sc_hd__decap_40_12
XFILLER_34_481 vssd1 vccd1 vccd1 vssd1 X2_sky130_fd_sc_hd__fill_2
XFILLER_42_27 vccd1 vssd1 vccd1 vssd1 X2_sky130_fd_sc_hd__fill_1
XPHY_EDGE_ROW_2_Left_104 vccd1 vssd1 vccd1 vssd1 X2_sky130_fd_sc_hd__decap_3
XFILLER_1_503 vccd1 vssd1 vccd1 vssd1 X2_sky130_fd_sc_hd__fill_1
XFILLER_88_153 vssd1 vccd1 vssd1 vccd1 X2_sky130_ef_sc_hd__decap_40_12
XFILLER_67_57 vssd1 vccd1 vssd1 vccd1 X2_sky130_ef_sc_hd__decap_40_12
XFILLER_67_35 vssd1 vccd1 vssd1 vccd1 X2_sky130_ef_sc_hd__decap_40_12
XFILLER_88_197 vssd1 vccd1 vssd1 vccd1 X2_sky130_ef_sc_hd__decap_40_12
XFILLER_57_573 vssd1 vccd1 vccd1 vssd1 X2_sky130_fd_sc_hd__fill_8
XFILLER_29_275 vssd1 vccd1 vccd1 vssd1 X2_sky130_fd_sc_hd__fill_2
X_552_ vssd1 vccd1 vccd1 vssd1 _553_/CLK _552_/D _472_/Y _552_/Q X2_sky130_fd_sc_hd__dfrtp_1
X_483_ vccd1 vssd1 vccd1 vssd1 _483_/Y _529_/A X2_sky130_fd_sc_hd__inv_2
XFILLER_72_587 vccd1 vssd1 vccd1 vssd1 X2_sky130_fd_sc_hd__fill_1
XFILLER_44_289 vssd1 vccd1 vssd1 vccd1 X2_sky130_ef_sc_hd__decap_40_12
XFILLER_16_83 vccd1 vssd1 vccd1 vssd1 X2_sky130_fd_sc_hd__fill_1
XFILLER_12_153 vssd1 vccd1 vssd1 vccd1 X2_sky130_ef_sc_hd__decap_40_12
XFILLER_40_473 vssd1 vccd1 vccd1 vssd1 X2_sky130_fd_sc_hd__fill_2
XTAP_TAPCELL_ROW_10_332 vccd1 vssd1 X2_sky130_fd_sc_hd__tapvpwrvgnd_1
XFILLER_12_197 vssd1 vccd1 vssd1 vccd1 X2_sky130_ef_sc_hd__decap_40_12
XPHY_EDGE_ROW_57_Left_159 vccd1 vssd1 vccd1 vssd1 X2_sky130_fd_sc_hd__decap_3
XANTENNA__343__A2 _304_/A vssd1 vccd1 vccd1 vssd1 X2_sky130_fd_sc_hd__diode_2
XFILLER_99_418 vssd1 vccd1 vccd1 vssd1 X2_sky130_fd_sc_hd__fill_4
XFILLER_4_363 vccd1 vssd1 vccd1 vssd1 X2_sky130_fd_sc_hd__fill_1
XTAP_TAPCELL_ROW_74_1039 vccd1 vssd1 X2_sky130_fd_sc_hd__tapvpwrvgnd_1
XFILLER_95_613 vssd1 vccd1 vccd1 vssd1 X2_sky130_fd_sc_hd__fill_2
XFILLER_67_337 vssd1 vccd1 vssd1 vccd1 X2_sky130_ef_sc_hd__decap_40_12
XFILLER_67_326 vssd1 vccd1 vccd1 vssd1 X2_sky130_fd_sc_hd__fill_8
XFILLER_82_307 vccd1 vssd1 vccd1 vssd1 X2_sky130_fd_sc_hd__fill_1
XPHY_EDGE_ROW_66_Left_168 vccd1 vssd1 vccd1 vssd1 X2_sky130_fd_sc_hd__decap_3
XFILLER_94_189 vssd1 vccd1 vccd1 vssd1 X2_sky130_fd_sc_hd__fill_4
XFILLER_48_573 vssd1 vccd1 vssd1 vccd1 X2_sky130_ef_sc_hd__decap_40_12
XTAP_TAPCELL_ROW_18_421 vccd1 vssd1 X2_sky130_fd_sc_hd__tapvpwrvgnd_1
XTAP_TAPCELL_ROW_85_1157 vccd1 vssd1 X2_sky130_fd_sc_hd__tapvpwrvgnd_1
XTAP_TAPCELL_ROW_46_730 vccd1 vssd1 X2_sky130_fd_sc_hd__tapvpwrvgnd_1
XFILLER_23_429 vssd1 vccd1 vssd1 vccd1 X2_sky130_ef_sc_hd__decap_40_12
XFILLER_35_278 vssd1 vccd1 vccd1 vssd1 X2_sky130_fd_sc_hd__fill_2
XFILLER_90_362 vssd1 vccd1 vccd1 vssd1 X2_sky130_fd_sc_hd__fill_2
XANTENNA__492__A _517_/A vssd1 vccd1 vccd1 vssd1 X2_sky130_fd_sc_hd__diode_2
XFILLER_31_473 vssd1 vccd1 vssd1 vccd1 X2_sky130_ef_sc_hd__decap_40_12
XPHY_EDGE_ROW_75_Left_177 vccd1 vssd1 vccd1 vssd1 X2_sky130_fd_sc_hd__decap_3
XANTENNA__319__C1 _303_/X vssd1 vccd1 vccd1 vssd1 X2_sky130_fd_sc_hd__diode_2
XANTENNA__334__A2 _317_/B vssd1 vccd1 vccd1 vssd1 X2_sky130_fd_sc_hd__diode_2
XTAP_TAPCELL_ROW_96_1275 vccd1 vssd1 X2_sky130_fd_sc_hd__tapvpwrvgnd_1
XFILLER_86_613 vssd1 vccd1 vccd1 vssd1 X2_sky130_fd_sc_hd__fill_8
XFILLER_86_624 vccd1 vssd1 vccd1 vssd1 X2_sky130_fd_sc_hd__fill_1
XPHY_EDGE_ROW_84_Left_186 vccd1 vssd1 vccd1 vssd1 X2_sky130_fd_sc_hd__decap_3
XFILLER_58_337 vssd1 vccd1 vccd1 vssd1 X2_sky130_fd_sc_hd__fill_2
XFILLER_58_326 vssd1 vccd1 vccd1 vssd1 X2_sky130_fd_sc_hd__fill_2
XFILLER_37_27 vssd1 vccd1 vssd1 vccd1 X2_sky130_ef_sc_hd__decap_40_12
XFILLER_100_445 vssd1 vccd1 vssd1 vccd1 X2_sky130_ef_sc_hd__decap_40_12
XFILLER_85_167 vccd1 vssd1 vccd1 vssd1 X2_sky130_fd_sc_hd__fill_1
XFILLER_39_573 vssd1 vccd1 vssd1 vccd1 X2_sky130_ef_sc_hd__decap_40_12
XFILLER_100_489 vssd1 vccd1 vssd1 vccd1 X2_sky130_ef_sc_hd__decap_40_12
XFILLER_73_329 vssd1 vccd1 vccd1 vssd1 X2_sky130_fd_sc_hd__fill_4
XFILLER_54_510 vssd1 vccd1 vssd1 vccd1 X2_sky130_ef_sc_hd__decap_40_12
XFILLER_26_245 vssd1 vccd1 vccd1 vssd1 X2_sky130_fd_sc_hd__fill_4
XFILLER_26_289 vssd1 vccd1 vssd1 vccd1 X2_sky130_ef_sc_hd__decap_40_12
XFILLER_81_373 vssd1 vccd1 vssd1 vccd1 X2_sky130_ef_sc_hd__decap_40_12
XFILLER_53_15 vssd1 vccd1 vssd1 vccd1 X2_sky130_ef_sc_hd__decap_40_12
XPHY_EDGE_ROW_93_Left_195 vccd1 vssd1 vccd1 vssd1 X2_sky130_fd_sc_hd__decap_3
XFILLER_10_613 vssd1 vccd1 vssd1 vccd1 X2_sky130_ef_sc_hd__decap_40_12
XFILLER_22_473 vssd1 vccd1 vccd1 vssd1 X2_sky130_fd_sc_hd__fill_2
XTAP_TAPCELL_ROW_24_479 vccd1 vssd1 X2_sky130_fd_sc_hd__tapvpwrvgnd_1
XTAP_TAPCELL_ROW_52_788 vccd1 vssd1 X2_sky130_fd_sc_hd__tapvpwrvgnd_1
XFILLER_5_105 vssd1 vccd1 vccd1 vssd1 X2_sky130_fd_sc_hd__fill_4
XANTENNA__325__A2 _317_/B vssd1 vccd1 vccd1 vssd1 X2_sky130_fd_sc_hd__diode_2
XFILLER_5_149 vssd1 vccd1 vssd1 vccd1 X2_sky130_ef_sc_hd__decap_40_12
XFILLER_1_333 vssd1 vccd1 vccd1 vssd1 X2_sky130_fd_sc_hd__fill_2
XFILLER_1_344 vssd1 vccd1 vccd1 vssd1 X2_sky130_fd_sc_hd__fill_2
XFILLER_89_473 vssd1 vccd1 vssd1 vccd1 X2_sky130_ef_sc_hd__decap_40_12
XFILLER_77_613 vssd1 vccd1 vccd1 vssd1 X2_sky130_fd_sc_hd__fill_2
XFILLER_49_337 vssd1 vccd1 vccd1 vssd1 X2_sky130_fd_sc_hd__fill_8
XFILLER_64_307 vccd1 vssd1 vccd1 vssd1 X2_sky130_fd_sc_hd__fill_1
XFILLER_49_359 vccd1 vssd1 vccd1 vssd1 X2_sky130_fd_sc_hd__fill_1
XFILLER_94_77 vssd1 vccd1 vccd1 vssd1 X2_sky130_fd_sc_hd__fill_4
XFILLER_76_189 vssd1 vccd1 vccd1 vssd1 X2_sky130_fd_sc_hd__fill_4
XFILLER_57_381 vssd1 vccd1 vccd1 vssd1 X2_sky130_fd_sc_hd__fill_8
XFILLER_45_521 vssd1 vccd1 vssd1 vccd1 X2_sky130_ef_sc_hd__decap_40_12
XFILLER_17_223 vccd1 vssd1 vccd1 vssd1 X2_sky130_fd_sc_hd__fill_1
XFILLER_91_137 vssd1 vccd1 vssd1 vccd1 X2_sky130_ef_sc_hd__decap_40_12
X_604_ vssd1 vccd1 vccd1 vssd1 _606_/CLK _604_/D _524_/Y _604_/Q X2_sky130_fd_sc_hd__dfrtp_1
XFILLER_27_93 vssd1 vccd1 vssd1 vccd1 X2_sky130_ef_sc_hd__decap_40_12
X_535_ vssd1 vccd1 vccd1 vssd1 _553_/CLK _535_/D _455_/Y _535_/Q X2_sky130_fd_sc_hd__dfrtp_4
XFILLER_60_513 vssd1 vccd1 vssd1 vccd1 X2_sky130_ef_sc_hd__decap_40_12
XFILLER_45_576 vssd1 vccd1 vssd1 vccd1 X2_sky130_ef_sc_hd__decap_40_12
XFILLER_32_215 vssd1 vccd1 vccd1 vssd1 X2_sky130_fd_sc_hd__fill_2
XFILLER_32_237 vssd1 vccd1 vssd1 vccd1 X2_sky130_ef_sc_hd__decap_40_12
XFILLER_60_557 vssd1 vccd1 vssd1 vccd1 X2_sky130_ef_sc_hd__decap_40_12
X_466_ vccd1 vssd1 vccd1 vssd1 _466_/Y _529_/A X2_sky130_fd_sc_hd__inv_2
XFILLER_13_473 vssd1 vccd1 vssd1 vccd1 X2_sky130_ef_sc_hd__decap_40_12
X_397_ vssd1 vccd1 _420_/A _377_/Y _425_/B _394_/Y vccd1 vssd1 X2_sky130_fd_sc_hd__o21ai_2
XFILLER_43_81 vssd1 vccd1 vssd1 vccd1 X2_sky130_ef_sc_hd__decap_40_12
XTAP_TAPCELL_ROW_80_1098 vccd1 vssd1 X2_sky130_fd_sc_hd__tapvpwrvgnd_1
XANTENNA__316__A2 _303_/X vssd1 vccd1 vccd1 vssd1 X2_sky130_fd_sc_hd__diode_2
XFILLER_4_193 vssd1 vccd1 vccd1 vssd1 X2_sky130_fd_sc_hd__fill_2
XFILLER_99_237 vssd1 vccd1 vssd1 vccd1 X2_sky130_ef_sc_hd__decap_40_12
XFILLER_4_53 vssd1 vccd1 vssd1 vccd1 X2_sky130_ef_sc_hd__decap_40_12
XFILLER_4_97 vssd1 vccd1 vssd1 vccd1 X2_sky130_ef_sc_hd__decap_40_12
XFILLER_68_624 vccd1 vssd1 vccd1 vssd1 X2_sky130_fd_sc_hd__fill_1
XANTENNA__487__A _521_/A vssd1 vccd1 vccd1 vssd1 X2_sky130_fd_sc_hd__diode_2
XFILLER_67_167 vccd1 vssd1 vccd1 vssd1 X2_sky130_fd_sc_hd__fill_1
XFILLER_82_137 vssd1 vccd1 vccd1 vssd1 X2_sky130_fd_sc_hd__fill_2
XFILLER_36_587 vccd1 vssd1 vccd1 vssd1 X2_sky130_fd_sc_hd__fill_1
XFILLER_63_373 vssd1 vccd1 vssd1 vccd1 X2_sky130_ef_sc_hd__decap_40_12
XFILLER_23_237 vssd1 vccd1 vssd1 vccd1 X2_sky130_ef_sc_hd__decap_40_12
XFILLER_36_598 vssd1 vccd1 vccd1 vssd1 X2_sky130_fd_sc_hd__fill_2
XFILLER_51_557 vssd1 vccd1 vccd1 vssd1 X2_sky130_fd_sc_hd__fill_2
XTAP_TAPCELL_ROW_21_449 vccd1 vssd1 X2_sky130_fd_sc_hd__tapvpwrvgnd_1
XFILLER_31_281 vssd1 vccd1 vssd1 vccd1 X2_sky130_ef_sc_hd__decap_40_12
XANTENNA__307__A2 _303_/X vssd1 vccd1 vccd1 vssd1 X2_sky130_fd_sc_hd__diode_2
XFILLER_3_609 vssd1 vccd1 vccd1 vssd1 X2_sky130_fd_sc_hd__fill_4
XFILLER_59_602 vssd1 vccd1 vccd1 vssd1 X2_sky130_fd_sc_hd__fill_2
XFILLER_48_15 vssd1 vccd1 vssd1 vccd1 X2_sky130_ef_sc_hd__decap_40_12
XFILLER_86_421 vssd1 vccd1 vssd1 vccd1 X2_sky130_ef_sc_hd__decap_40_12
XFILLER_100_253 vssd1 vccd1 vssd1 vccd1 X2_sky130_ef_sc_hd__decap_40_12
XFILLER_58_189 vssd1 vccd1 vccd1 vssd1 X2_sky130_fd_sc_hd__fill_4
XTAP_TAPCELL_ROW_29_538 vccd1 vssd1 X2_sky130_fd_sc_hd__tapvpwrvgnd_1
XFILLER_73_137 vssd1 vccd1 vssd1 vccd1 X2_sky130_ef_sc_hd__decap_40_12
XTAP_TAPCELL_ROW_57_847 vccd1 vssd1 X2_sky130_fd_sc_hd__tapvpwrvgnd_1
XANTENNA__547__D _547_/D vssd1 vccd1 vccd1 vssd1 X2_sky130_fd_sc_hd__diode_2
XFILLER_81_181 vssd1 vccd1 vssd1 vccd1 X2_sky130_ef_sc_hd__decap_40_12
X_320_ vssd1 vccd1 vssd1 vccd1 _320_/X _341_/C _320_/C _320_/B _320_/A X2_sky130_fd_sc_hd__and4_4
XFILLER_42_546 vssd1 vccd1 vccd1 vssd1 X2_sky130_fd_sc_hd__fill_8
Xfanout63 vccd1 vssd1 vssd1 vccd1 _527_/A _517_/A X2_sky130_fd_sc_hd__buf_8
XFILLER_10_421 vssd1 vccd1 vssd1 vccd1 X2_sky130_ef_sc_hd__decap_40_12
XFILLER_13_51 vssd1 vccd1 vccd1 vssd1 X2_sky130_fd_sc_hd__fill_4
XFILLER_6_469 vssd1 vccd1 vccd1 vssd1 X2_sky130_fd_sc_hd__fill_4
XFILLER_89_55 vccd1 vssd1 vccd1 vssd1 X2_sky130_fd_sc_hd__fill_1
XFILLER_89_281 vccd1 vssd1 vccd1 vssd1 X2_sky130_fd_sc_hd__fill_1
XFILLER_38_81 vssd1 vccd1 vccd1 vssd1 X2_sky130_fd_sc_hd__fill_2
XFILLER_92_413 vssd1 vccd1 vccd1 vssd1 X2_sky130_fd_sc_hd__fill_4
XFILLER_49_167 vccd1 vssd1 vccd1 vssd1 X2_sky130_fd_sc_hd__fill_1
XFILLER_92_457 vssd1 vccd1 vssd1 vccd1 X2_sky130_ef_sc_hd__decap_40_12
XFILLER_64_137 vssd1 vccd1 vccd1 vssd1 X2_sky130_fd_sc_hd__fill_2
XFILLER_18_587 vccd1 vssd1 vccd1 vssd1 X2_sky130_fd_sc_hd__fill_1
XTAP_TAPCELL_ROW_82_1127 vccd1 vssd1 X2_sky130_fd_sc_hd__tapvpwrvgnd_1
XFILLER_45_373 vssd1 vccd1 vssd1 vccd1 X2_sky130_ef_sc_hd__decap_40_12
X_518_ vccd1 vssd1 vccd1 vssd1 _518_/Y _521_/A X2_sky130_fd_sc_hd__inv_2
XFILLER_60_365 vssd1 vccd1 vssd1 vccd1 X2_sky130_ef_sc_hd__decap_40_12
X_449_ vccd1 vssd1 vccd1 vssd1 hold48/X _588_/D _449_/A1 _440_/Y X2_sky130_fd_sc_hd__a21boi_1
XFILLER_13_281 vssd1 vccd1 vssd1 vccd1 X2_sky130_ef_sc_hd__decap_40_12
XFILLER_62_3 vssd1 vccd1 vssd1 vccd1 X2_sky130_ef_sc_hd__decap_40_12
XTAP_TAPCELL_ROW_93_1245 vccd1 vssd1 X2_sky130_fd_sc_hd__tapvpwrvgnd_1
XFILLER_68_421 vssd1 vccd1 vssd1 vccd1 X2_sky130_ef_sc_hd__decap_40_12
XFILLER_18_29 vssd1 vccd1 vssd1 vccd1 X2_sky130_ef_sc_hd__decap_40_12
XFILLER_28_307 vccd1 vssd1 vccd1 vssd1 X2_sky130_fd_sc_hd__fill_1
XFILLER_95_273 vssd1 vccd1 vccd1 vssd1 X2_sky130_fd_sc_hd__fill_4
XFILLER_55_137 vssd1 vccd1 vssd1 vccd1 X2_sky130_ef_sc_hd__decap_40_12
XTAP_TAPCELL_ROW_26_508 vccd1 vssd1 X2_sky130_fd_sc_hd__tapvpwrvgnd_1
XFILLER_71_619 vccd1 vssd1 vccd1 vssd1 X2_sky130_fd_sc_hd__fill_1
XTAP_TAPCELL_ROW_54_817 vccd1 vssd1 X2_sky130_fd_sc_hd__tapvpwrvgnd_1
XFILLER_24_513 vssd1 vccd1 vssd1 vccd1 X2_sky130_ef_sc_hd__decap_40_12
XFILLER_63_181 vssd1 vccd1 vssd1 vccd1 X2_sky130_ef_sc_hd__decap_40_12
XFILLER_24_557 vssd1 vccd1 vssd1 vccd1 X2_sky130_ef_sc_hd__decap_40_12
XTAP_TAPCELL_ROW_34_596 vccd1 vssd1 X2_sky130_fd_sc_hd__tapvpwrvgnd_1
Xclkload5 vccd1 vssd1 vccd1 vssd1 clkload5/Y _607_/CLK X2_sky130_fd_sc_hd__inv_6
XFILLER_50_27 vccd1 vssd1 vccd1 vssd1 X2_sky130_fd_sc_hd__fill_1
XFILLER_3_417 vssd1 vccd1 vssd1 vccd1 X2_sky130_ef_sc_hd__decap_40_12
XFILLER_59_69 vssd1 vccd1 vssd1 vccd1 X2_sky130_ef_sc_hd__decap_40_12
XTAP_TAPCELL_ROW_6_288 vccd1 vssd1 X2_sky130_fd_sc_hd__tapvpwrvgnd_1
XFILLER_19_329 vssd1 vccd1 vccd1 vssd1 X2_sky130_fd_sc_hd__fill_4
XFILLER_101_573 vssd1 vccd1 vssd1 vccd1 X2_sky130_ef_sc_hd__decap_40_12
XFILLER_86_251 vccd1 vssd1 vccd1 vssd1 X2_sky130_fd_sc_hd__fill_1
XFILLER_74_413 vssd1 vccd1 vccd1 vssd1 X2_sky130_fd_sc_hd__fill_4
XFILLER_75_57 vssd1 vccd1 vssd1 vccd1 X2_sky130_ef_sc_hd__decap_40_12
XFILLER_74_457 vssd1 vccd1 vssd1 vccd1 X2_sky130_ef_sc_hd__decap_40_12
XFILLER_46_137 vssd1 vccd1 vccd1 vssd1 X2_sky130_fd_sc_hd__fill_2
XFILLER_27_373 vssd1 vccd1 vssd1 vccd1 X2_sky130_ef_sc_hd__decap_40_12
XFILLER_15_557 vssd1 vccd1 vccd1 vssd1 X2_sky130_fd_sc_hd__fill_2
X_303_ vssd1 vccd1 vssd1 vccd1 _303_/B _303_/A _303_/X X2_sky130_fd_sc_hd__or2_4
XFILLER_42_365 vssd1 vccd1 vccd1 vssd1 X2_sky130_fd_sc_hd__fill_2
XFILLER_24_83 vccd1 vssd1 vccd1 vssd1 X2_sky130_fd_sc_hd__fill_1
XFILLER_10_251 vccd1 vssd1 vccd1 vssd1 X2_sky130_fd_sc_hd__fill_1
XFILLER_6_233 vssd1 vccd1 vssd1 vccd1 X2_sky130_ef_sc_hd__decap_40_12
XFILLER_6_277 vssd1 vccd1 vssd1 vccd1 X2_sky130_ef_sc_hd__decap_40_12
XFILLER_97_505 vssd1 vccd1 vssd1 vccd1 X2_sky130_ef_sc_hd__decap_40_12
XANTENNA_output50_A _558_/Q vssd1 vccd1 vccd1 vssd1 X2_sky130_fd_sc_hd__diode_2
XFILLER_77_273 vssd1 vccd1 vccd1 vssd1 X2_sky130_fd_sc_hd__fill_4
XFILLER_37_137 vssd1 vccd1 vssd1 vccd1 X2_sky130_ef_sc_hd__decap_40_12
XFILLER_92_221 vssd1 vccd1 vssd1 vccd1 X2_sky130_ef_sc_hd__decap_40_12
XFILLER_92_265 vccd1 vssd1 vccd1 vssd1 X2_sky130_fd_sc_hd__fill_1
XFILLER_45_181 vssd1 vccd1 vssd1 vccd1 X2_sky130_ef_sc_hd__decap_40_12
XFILLER_21_505 vssd1 vccd1 vssd1 vccd1 X2_sky130_ef_sc_hd__decap_40_12
XFILLER_33_387 vssd1 vccd1 vccd1 vssd1 X2_sky130_fd_sc_hd__fill_2
XFILLER_60_195 vccd1 vssd1 vccd1 vssd1 X2_sky130_fd_sc_hd__fill_1
XTAP_TAPCELL_ROW_31_566 vccd1 vssd1 X2_sky130_fd_sc_hd__tapvpwrvgnd_1
XFILLER_29_39 vssd1 vccd1 vssd1 vccd1 X2_sky130_ef_sc_hd__decap_40_12
XANTENNA__446__A1 _446_/A1 vssd1 vccd1 vccd1 vssd1 X2_sky130_fd_sc_hd__diode_2
Xhold17 hold17/X _562_/Q vccd1 vssd1 vssd1 vccd1 X2_sky130_fd_sc_hd__dlygate4sd3_1
Xhold28 hold28/X _565_/Q vccd1 vssd1 vssd1 vccd1 X2_sky130_fd_sc_hd__dlygate4sd3_1
Xhold39 _567_/D _314_/X vccd1 vssd1 vssd1 vccd1 X2_sky130_fd_sc_hd__dlygate4sd3_1
XFILLER_68_251 vccd1 vssd1 vccd1 vssd1 X2_sky130_fd_sc_hd__fill_1
XFILLER_56_413 vssd1 vccd1 vccd1 vssd1 X2_sky130_fd_sc_hd__fill_4
XTAP_TAPCELL_ROW_3_258 vccd1 vssd1 X2_sky130_fd_sc_hd__tapvpwrvgnd_1
XFILLER_28_137 vssd1 vccd1 vccd1 vssd1 X2_sky130_fd_sc_hd__fill_2
XTAP_TAPCELL_ROW_39_644 vccd1 vssd1 X2_sky130_fd_sc_hd__tapvpwrvgnd_1
XFILLER_83_221 vssd1 vccd1 vccd1 vssd1 X2_sky130_fd_sc_hd__fill_2
XTAP_TAPCELL_ROW_67_953 vccd1 vssd1 X2_sky130_fd_sc_hd__tapvpwrvgnd_1
XFILLER_56_457 vssd1 vccd1 vssd1 vccd1 X2_sky130_ef_sc_hd__decap_40_12
XFILLER_83_276 vssd1 vccd1 vccd1 vssd1 X2_sky130_fd_sc_hd__fill_4
XFILLER_71_405 vssd1 vccd1 vssd1 vccd1 X2_sky130_ef_sc_hd__decap_40_12
XFILLER_45_27 vssd1 vccd1 vssd1 vccd1 X2_sky130_ef_sc_hd__decap_40_12
XFILLER_71_449 vssd1 vccd1 vssd1 vccd1 X2_sky130_ef_sc_hd__decap_40_12
XFILLER_24_321 vssd1 vccd1 vssd1 vccd1 X2_sky130_ef_sc_hd__decap_40_12
XFILLER_24_365 vssd1 vccd1 vssd1 vccd1 X2_sky130_ef_sc_hd__decap_40_12
XFILLER_101_55 vccd1 vssd1 vccd1 vssd1 X2_sky130_fd_sc_hd__fill_1
XFILLER_61_15 vssd1 vccd1 vssd1 vccd1 X2_sky130_ef_sc_hd__decap_40_12
XFILLER_3_225 vssd1 vccd1 vssd1 vccd1 X2_sky130_ef_sc_hd__decap_40_12
XFILLER_10_41 vssd1 vccd1 vssd1 vccd1 X2_sky130_ef_sc_hd__decap_40_12
XFILLER_79_505 vssd1 vccd1 vssd1 vccd1 X2_sky130_ef_sc_hd__decap_40_12
XFILLER_10_85 vssd1 vccd1 vssd1 vccd1 X2_sky130_ef_sc_hd__decap_40_12
XFILLER_19_137 vssd1 vccd1 vssd1 vccd1 X2_sky130_ef_sc_hd__decap_40_12
XFILLER_74_221 vssd1 vccd1 vssd1 vccd1 X2_sky130_ef_sc_hd__decap_40_12
XFILLER_74_265 vssd1 vccd1 vssd1 vccd1 X2_sky130_ef_sc_hd__decap_40_12
XFILLER_47_468 vssd1 vccd1 vssd1 vccd1 X2_sky130_ef_sc_hd__decap_40_12
XFILLER_27_181 vssd1 vccd1 vssd1 vccd1 X2_sky130_ef_sc_hd__decap_40_12
XFILLER_35_93 vssd1 vccd1 vssd1 vccd1 X2_sky130_ef_sc_hd__decap_40_12
XFILLER_42_195 vccd1 vssd1 vccd1 vssd1 X2_sky130_fd_sc_hd__fill_1
XFILLER_51_81 vssd1 vccd1 vssd1 vccd1 X2_sky130_ef_sc_hd__decap_40_12
XFILLER_7_553 vssd1 vccd1 vccd1 vssd1 X2_sky130_fd_sc_hd__fill_4
XFILLER_7_597 vssd1 vccd1 vssd1 vccd1 X2_sky130_ef_sc_hd__decap_40_12
XTAP_TAPCELL_ROW_90_1215 vccd1 vssd1 X2_sky130_fd_sc_hd__tapvpwrvgnd_1
XFILLER_97_346 vssd1 vccd1 vccd1 vssd1 X2_sky130_fd_sc_hd__fill_2
XFILLER_25_3 vssd1 vccd1 vssd1 vccd1 X2_sky130_ef_sc_hd__decap_40_12
XANTENNA__428__B2 _547_/D vssd1 vccd1 vccd1 vssd1 X2_sky130_fd_sc_hd__diode_2
XFILLER_38_424 vssd1 vccd1 vccd1 vssd1 X2_sky130_fd_sc_hd__fill_2
XFILLER_93_541 vssd1 vccd1 vssd1 vccd1 X2_sky130_ef_sc_hd__decap_40_12
XFILLER_65_221 vssd1 vccd1 vccd1 vssd1 X2_sky130_fd_sc_hd__fill_2
XTAP_TAPCELL_ROW_0_206 vccd1 vssd1 X2_sky130_fd_sc_hd__tapvpwrvgnd_1
XTAP_TAPCELL_ROW_0_217 vccd1 vssd1 X2_sky130_fd_sc_hd__tapvpwrvgnd_1
XTAP_TAPCELL_ROW_36_614 vccd1 vssd1 X2_sky130_fd_sc_hd__tapvpwrvgnd_1
XTAP_TAPCELL_ROW_88_1188 vccd1 vssd1 X2_sky130_fd_sc_hd__tapvpwrvgnd_1
XFILLER_93_585 vssd1 vccd1 vssd1 vccd1 X2_sky130_ef_sc_hd__decap_40_12
XTAP_TAPCELL_ROW_64_923 vccd1 vssd1 X2_sky130_fd_sc_hd__tapvpwrvgnd_1
XFILLER_53_449 vccd1 vssd1 vccd1 vssd1 X2_sky130_fd_sc_hd__fill_1
XTAP_TAPCELL_ROW_16_393 vccd1 vssd1 X2_sky130_fd_sc_hd__tapvpwrvgnd_1
XFILLER_21_335 vccd1 vssd1 vccd1 vssd1 X2_sky130_fd_sc_hd__fill_1
XTAP_TAPCELL_ROW_8_306 vccd1 vssd1 X2_sky130_fd_sc_hd__tapvpwrvgnd_1
XFILLER_88_368 vssd1 vccd1 vssd1 vccd1 X2_sky130_ef_sc_hd__decap_40_12
XFILLER_56_221 vssd1 vccd1 vssd1 vccd1 X2_sky130_ef_sc_hd__decap_40_12
XFILLER_56_15 vssd1 vccd1 vssd1 vccd1 X2_sky130_ef_sc_hd__decap_40_12
XFILLER_56_265 vssd1 vccd1 vccd1 vssd1 X2_sky130_fd_sc_hd__fill_4
XFILLER_84_585 vssd1 vccd1 vccd1 vssd1 X2_sky130_fd_sc_hd__fill_2
XFILLER_40_611 vssd1 vccd1 vccd1 vssd1 X2_sky130_fd_sc_hd__fill_8
XFILLER_71_279 vccd1 vssd1 vccd1 vssd1 X2_sky130_fd_sc_hd__fill_1
XFILLER_24_195 vccd1 vssd1 vccd1 vssd1 X2_sky130_fd_sc_hd__fill_1
XFILLER_12_357 vssd1 vccd1 vccd1 vssd1 X2_sky130_fd_sc_hd__fill_4
XFILLER_4_501 vssd1 vccd1 vssd1 vccd1 X2_sky130_ef_sc_hd__decap_40_12
XFILLER_21_51 vssd1 vccd1 vccd1 vssd1 X2_sky130_fd_sc_hd__fill_4
XFILLER_4_545 vssd1 vccd1 vssd1 vccd1 X2_sky130_ef_sc_hd__decap_40_12
XFILLER_4_589 vssd1 vccd1 vssd1 vccd1 X2_sky130_ef_sc_hd__decap_40_12
XFILLER_97_55 vccd1 vssd1 vccd1 vssd1 X2_sky130_fd_sc_hd__fill_1
XFILLER_79_335 vccd1 vssd1 vccd1 vssd1 X2_sky130_fd_sc_hd__fill_1
XFILLER_87_390 vssd1 vccd1 vccd1 vssd1 X2_sky130_fd_sc_hd__fill_2
XFILLER_35_405 vssd1 vccd1 vssd1 vccd1 X2_sky130_ef_sc_hd__decap_40_12
XFILLER_75_541 vssd1 vccd1 vssd1 vccd1 X2_sky130_ef_sc_hd__decap_40_12
XFILLER_90_533 vssd1 vccd1 vssd1 vccd1 X2_sky130_ef_sc_hd__decap_40_12
XFILLER_75_585 vssd1 vccd1 vccd1 vssd1 X2_sky130_fd_sc_hd__fill_2
XFILLER_62_213 vssd1 vccd1 vssd1 vccd1 X2_sky130_ef_sc_hd__decap_40_12
XFILLER_35_449 vssd1 vccd1 vssd1 vccd1 X2_sky130_ef_sc_hd__decap_40_12
XFILLER_46_81 vssd1 vccd1 vccd1 vssd1 X2_sky130_fd_sc_hd__fill_2
XFILLER_30_121 vssd1 vccd1 vssd1 vccd1 X2_sky130_ef_sc_hd__decap_40_12
XTAP_TAPCELL_ROW_13_363 vccd1 vssd1 X2_sky130_fd_sc_hd__tapvpwrvgnd_1
XFILLER_30_165 vssd1 vccd1 vssd1 vccd1 X2_sky130_ef_sc_hd__decap_40_12
XTAP_TAPCELL_ROW_41_672 vccd1 vssd1 X2_sky130_fd_sc_hd__tapvpwrvgnd_1
XFILLER_7_361 vssd1 vccd1 vssd1 vccd1 X2_sky130_ef_sc_hd__decap_40_12
XFILLER_97_165 vssd1 vccd1 vccd1 vssd1 X2_sky130_fd_sc_hd__fill_2
XFILLER_85_305 vssd1 vccd1 vssd1 vccd1 X2_sky130_ef_sc_hd__decap_40_12
XFILLER_38_221 vssd1 vccd1 vssd1 vccd1 X2_sky130_ef_sc_hd__decap_40_12
XFILLER_85_349 vssd1 vccd1 vssd1 vccd1 X2_sky130_ef_sc_hd__decap_40_12
XFILLER_26_29 vssd1 vccd1 vssd1 vccd1 X2_sky130_ef_sc_hd__decap_40_12
XFILLER_38_287 vssd1 vccd1 vccd1 vssd1 X2_sky130_fd_sc_hd__fill_2
XFILLER_66_585 vssd1 vccd1 vccd1 vssd1 X2_sky130_fd_sc_hd__fill_2
XFILLER_53_213 vssd1 vccd1 vccd1 vssd1 X2_sky130_fd_sc_hd__fill_2
XTAP_TAPCELL_ROW_49_761 vccd1 vssd1 X2_sky130_fd_sc_hd__tapvpwrvgnd_1
XPHY_EDGE_ROW_5_Right_5 vccd1 vssd1 vccd1 vssd1 X2_sky130_fd_sc_hd__decap_3
XFILLER_93_393 vssd1 vccd1 vssd1 vccd1 X2_sky130_ef_sc_hd__decap_40_12
XFILLER_53_257 vssd1 vccd1 vccd1 vssd1 X2_sky130_fd_sc_hd__fill_2
XFILLER_53_279 vccd1 vssd1 vccd1 vssd1 X2_sky130_fd_sc_hd__fill_1
XFILLER_21_165 vssd1 vccd1 vccd1 vssd1 X2_sky130_fd_sc_hd__fill_2
XFILLER_1_559 vccd1 vssd1 vccd1 vssd1 X2_sky130_fd_sc_hd__fill_1
XFILLER_88_121 vssd1 vccd1 vssd1 vccd1 X2_sky130_ef_sc_hd__decap_40_12
XFILLER_88_165 vssd1 vccd1 vssd1 vccd1 X2_sky130_ef_sc_hd__decap_40_12
XFILLER_67_47 vssd1 vccd1 vccd1 vssd1 X2_sky130_fd_sc_hd__fill_8
XFILLER_29_221 vssd1 vccd1 vccd1 vssd1 X2_sky130_fd_sc_hd__fill_2
XFILLER_67_69 vssd1 vccd1 vssd1 vccd1 X2_sky130_ef_sc_hd__decap_40_12
XFILLER_57_541 vssd1 vccd1 vssd1 vccd1 X2_sky130_ef_sc_hd__decap_40_12
XFILLER_17_405 vssd1 vccd1 vssd1 vccd1 X2_sky130_ef_sc_hd__decap_40_12
X_551_ vssd1 vccd1 vccd1 vssd1 _553_/CLK _551_/D _471_/Y _551_/Q X2_sky130_fd_sc_hd__dfrtp_1
XFILLER_44_202 vssd1 vccd1 vssd1 vccd1 X2_sky130_ef_sc_hd__decap_40_12
XFILLER_17_449 vssd1 vccd1 vssd1 vccd1 X2_sky130_ef_sc_hd__decap_40_12
XFILLER_83_57 vssd1 vccd1 vssd1 vccd1 X2_sky130_ef_sc_hd__decap_40_12
XFILLER_72_533 vssd1 vccd1 vssd1 vccd1 X2_sky130_ef_sc_hd__decap_40_12
X_482_ vccd1 vssd1 vccd1 vssd1 _482_/Y _517_/A X2_sky130_fd_sc_hd__inv_2
XFILLER_72_599 vssd1 vccd1 vccd1 vssd1 X2_sky130_fd_sc_hd__fill_2
XFILLER_9_615 vccd1 vssd1 vccd1 vssd1 X2_sky130_fd_sc_hd__fill_1
XFILLER_12_121 vssd1 vccd1 vssd1 vccd1 X2_sky130_ef_sc_hd__decap_40_12
XFILLER_12_165 vssd1 vccd1 vssd1 vccd1 X2_sky130_ef_sc_hd__decap_40_12
XTAP_TAPCELL_ROW_10_333 vccd1 vssd1 X2_sky130_fd_sc_hd__tapvpwrvgnd_1
XFILLER_32_83 vccd1 vssd1 vccd1 vssd1 X2_sky130_fd_sc_hd__fill_1
XTAP_TAPCELL_ROW_74_1029 vccd1 vssd1 X2_sky130_fd_sc_hd__tapvpwrvgnd_1
XFILLER_79_165 vssd1 vccd1 vccd1 vssd1 X2_sky130_fd_sc_hd__fill_2
XFILLER_67_349 vssd1 vccd1 vssd1 vccd1 X2_sky130_ef_sc_hd__decap_40_12
XFILLER_48_552 vccd1 vssd1 vccd1 vssd1 X2_sky130_fd_sc_hd__fill_1
XFILLER_48_541 vssd1 vccd1 vccd1 vssd1 X2_sky130_fd_sc_hd__fill_2
XFILLER_48_585 vssd1 vccd1 vccd1 vssd1 X2_sky130_fd_sc_hd__fill_2
XTAP_TAPCELL_ROW_18_422 vccd1 vssd1 X2_sky130_fd_sc_hd__tapvpwrvgnd_1
XFILLER_75_393 vssd1 vccd1 vssd1 vccd1 X2_sky130_ef_sc_hd__decap_40_12
XTAP_TAPCELL_ROW_46_731 vccd1 vssd1 X2_sky130_fd_sc_hd__tapvpwrvgnd_1
XTAP_TAPCELL_ROW_85_1158 vccd1 vssd1 X2_sky130_fd_sc_hd__tapvpwrvgnd_1
XFILLER_63_599 vccd1 vssd1 vccd1 vssd1 X2_sky130_fd_sc_hd__fill_1
XFILLER_31_441 vssd1 vccd1 vccd1 vssd1 X2_sky130_fd_sc_hd__fill_4
XFILLER_92_3 vssd1 vccd1 vssd1 vccd1 X2_sky130_ef_sc_hd__decap_40_12
XFILLER_31_485 vssd1 vccd1 vssd1 vccd1 X2_sky130_ef_sc_hd__decap_40_12
XTAP_TAPCELL_ROW_96_1276 vccd1 vssd1 X2_sky130_fd_sc_hd__tapvpwrvgnd_1
XANTENNA__538__CLK _601_/CLK vssd1 vccd1 vccd1 vssd1 X2_sky130_fd_sc_hd__diode_2
XFILLER_98_430 vssd1 vccd1 vccd1 vssd1 X2_sky130_fd_sc_hd__fill_2
XFILLER_85_113 vssd1 vccd1 vssd1 vccd1 X2_sky130_ef_sc_hd__decap_40_12
XFILLER_37_39 vssd1 vccd1 vssd1 vccd1 X2_sky130_ef_sc_hd__decap_40_12
XFILLER_100_457 vssd1 vccd1 vssd1 vccd1 X2_sky130_ef_sc_hd__decap_40_12
XFILLER_39_585 vssd1 vccd1 vssd1 vccd1 X2_sky130_ef_sc_hd__decap_40_12
XFILLER_54_522 vssd1 vccd1 vccd1 vssd1 X2_sky130_fd_sc_hd__fill_8
XFILLER_54_533 vssd1 vccd1 vccd1 vssd1 X2_sky130_fd_sc_hd__fill_8
XFILLER_14_419 vccd1 vssd1 vccd1 vssd1 X2_sky130_fd_sc_hd__fill_1
XFILLER_53_27 vssd1 vccd1 vssd1 vccd1 X2_sky130_ef_sc_hd__decap_40_12
XFILLER_81_385 vssd1 vccd1 vccd1 vssd1 X2_sky130_fd_sc_hd__fill_4
XTAP_TAPCELL_ROW_52_789 vccd1 vssd1 X2_sky130_fd_sc_hd__tapvpwrvgnd_1
XFILLER_89_441 vssd1 vccd1 vccd1 vssd1 X2_sky130_fd_sc_hd__fill_4
XFILLER_49_305 vssd1 vccd1 vssd1 vccd1 X2_sky130_ef_sc_hd__decap_40_12
XFILLER_89_485 vssd1 vccd1 vssd1 vccd1 X2_sky130_ef_sc_hd__decap_40_12
XFILLER_91_105 vssd1 vccd1 vccd1 vssd1 X2_sky130_fd_sc_hd__fill_4
X_603_ vssd1 vccd1 vccd1 vssd1 _606_/CLK _603_/D _523_/Y hold7/A X2_sky130_fd_sc_hd__dfrtp_1
XFILLER_91_149 vssd1 vccd1 vssd1 vccd1 X2_sky130_ef_sc_hd__decap_40_12
XANTENNA_input12_A adc_data_in[9] vssd1 vccd1 vccd1 vssd1 X2_sky130_fd_sc_hd__diode_2
XFILLER_57_393 vssd1 vccd1 vssd1 vccd1 X2_sky130_ef_sc_hd__decap_40_12
XFILLER_45_533 vssd1 vccd1 vssd1 vccd1 X2_sky130_ef_sc_hd__decap_40_12
XFILLER_17_279 vccd1 vssd1 vccd1 vssd1 X2_sky130_fd_sc_hd__fill_1
X_534_ vssd1 vccd1 vccd1 vssd1 _608_/CLK _534_/D _454_/Y _534_/Q X2_sky130_fd_sc_hd__dfrtp_4
XFILLER_72_363 vccd1 vssd1 vccd1 vssd1 X2_sky130_fd_sc_hd__fill_1
XFILLER_45_588 vssd1 vccd1 vssd1 vccd1 X2_sky130_ef_sc_hd__decap_40_12
X_465_ vccd1 vssd1 vccd1 vssd1 _465_/Y _529_/A X2_sky130_fd_sc_hd__inv_2
XFILLER_60_525 vssd1 vccd1 vccd1 vssd1 X2_sky130_fd_sc_hd__fill_4
XFILLER_13_441 vssd1 vccd1 vccd1 vssd1 X2_sky130_fd_sc_hd__fill_4
XFILLER_32_249 vssd1 vccd1 vccd1 vssd1 X2_sky130_fd_sc_hd__fill_2
XFILLER_60_569 vssd1 vccd1 vssd1 vccd1 X2_sky130_ef_sc_hd__decap_40_12
XFILLER_13_485 vssd1 vccd1 vssd1 vccd1 X2_sky130_ef_sc_hd__decap_40_12
X_396_ vssd1 vccd1 _395_/X _377_/B _420_/A _394_/Y vccd1 vssd1 X2_sky130_fd_sc_hd__o21ai_2
XFILLER_43_93 vssd1 vccd1 vssd1 vccd1 X2_sky130_ef_sc_hd__decap_40_12
XFILLER_9_445 vssd1 vccd1 vccd1 vssd1 X2_sky130_fd_sc_hd__fill_2
XTAP_TAPCELL_ROW_80_1099 vccd1 vssd1 X2_sky130_fd_sc_hd__tapvpwrvgnd_1
XFILLER_64_7 vssd1 vccd1 vccd1 vssd1 X2_sky130_fd_sc_hd__fill_2
XFILLER_99_205 vssd1 vccd1 vssd1 vccd1 X2_sky130_ef_sc_hd__decap_40_12
XFILLER_99_249 vssd1 vccd1 vssd1 vccd1 X2_sky130_ef_sc_hd__decap_40_12
XFILLER_4_65 vssd1 vccd1 vssd1 vccd1 X2_sky130_ef_sc_hd__decap_40_12
XFILLER_67_113 vssd1 vccd1 vssd1 vccd1 X2_sky130_ef_sc_hd__decap_40_12
XFILLER_83_617 vssd1 vccd1 vccd1 vssd1 X2_sky130_fd_sc_hd__fill_8
XFILLER_55_308 vssd1 vccd1 vssd1 vccd1 X2_sky130_ef_sc_hd__decap_40_12
XFILLER_36_533 vssd1 vccd1 vssd1 vccd1 X2_sky130_ef_sc_hd__decap_40_12
XFILLER_23_205 vssd1 vccd1 vssd1 vccd1 X2_sky130_ef_sc_hd__decap_40_12
XFILLER_36_577 vssd1 vccd1 vccd1 vssd1 X2_sky130_fd_sc_hd__fill_8
XFILLER_63_385 vssd1 vccd1 vccd1 vssd1 X2_sky130_fd_sc_hd__fill_4
XFILLER_23_249 vssd1 vccd1 vssd1 vccd1 X2_sky130_ef_sc_hd__decap_40_12
XFILLER_90_193 vssd1 vccd1 vccd1 vssd1 X2_sky130_fd_sc_hd__fill_2
XFILLER_51_569 vssd1 vccd1 vccd1 vssd1 X2_sky130_fd_sc_hd__fill_2
XFILLER_31_293 vssd1 vccd1 vssd1 vccd1 X2_sky130_ef_sc_hd__decap_40_12
XFILLER_2_109 vssd1 vccd1 vssd1 vccd1 X2_sky130_ef_sc_hd__decap_40_12
XANTENNA_input4_A adc_data_in[1] vssd1 vccd1 vccd1 vssd1 X2_sky130_fd_sc_hd__diode_2
XFILLER_86_433 vssd1 vccd1 vssd1 vccd1 X2_sky130_ef_sc_hd__decap_40_12
XFILLER_48_27 vccd1 vssd1 vccd1 vssd1 X2_sky130_fd_sc_hd__fill_1
XFILLER_98_293 vssd1 vccd1 vccd1 vssd1 X2_sky130_fd_sc_hd__fill_2
XFILLER_100_221 vssd1 vccd1 vssd1 vccd1 X2_sky130_ef_sc_hd__decap_40_12
XFILLER_100_265 vssd1 vccd1 vssd1 vccd1 X2_sky130_ef_sc_hd__decap_40_12
XFILLER_86_477 vssd1 vccd1 vssd1 vccd1 X2_sky130_ef_sc_hd__decap_40_12
XFILLER_73_105 vssd1 vccd1 vccd1 vssd1 X2_sky130_fd_sc_hd__fill_4
XTAP_TAPCELL_ROW_29_539 vccd1 vssd1 X2_sky130_fd_sc_hd__tapvpwrvgnd_1
XFILLER_39_393 vssd1 vccd1 vssd1 vccd1 X2_sky130_ef_sc_hd__decap_40_12
XFILLER_73_149 vssd1 vccd1 vssd1 vccd1 X2_sky130_ef_sc_hd__decap_40_12
XTAP_TAPCELL_ROW_57_848 vccd1 vssd1 X2_sky130_fd_sc_hd__tapvpwrvgnd_1
XFILLER_14_249 vssd1 vccd1 vccd1 vssd1 X2_sky130_fd_sc_hd__fill_2
XFILLER_81_193 vssd1 vccd1 vssd1 vccd1 X2_sky130_ef_sc_hd__decap_40_12
Xfanout64 vccd1 vssd1 vssd1 vccd1 _525_/A _527_/A X2_sky130_fd_sc_hd__buf_8
XFILLER_10_433 vssd1 vccd1 vssd1 vccd1 X2_sky130_ef_sc_hd__decap_40_12
XFILLER_10_477 vssd1 vccd1 vssd1 vccd1 X2_sky130_ef_sc_hd__decap_40_12
XFILLER_49_113 vssd1 vccd1 vssd1 vccd1 X2_sky130_ef_sc_hd__decap_40_12
XFILLER_65_617 vssd1 vccd1 vccd1 vssd1 X2_sky130_fd_sc_hd__fill_2
XFILLER_18_533 vssd1 vccd1 vssd1 vccd1 X2_sky130_ef_sc_hd__decap_40_12
XFILLER_33_503 vccd1 vssd1 vccd1 vssd1 X2_sky130_fd_sc_hd__fill_1
XFILLER_92_469 vssd1 vccd1 vccd1 vssd1 X2_sky130_fd_sc_hd__fill_4
XFILLER_33_536 vssd1 vccd1 vccd1 vssd1 X2_sky130_fd_sc_hd__fill_2
XTAP_TAPCELL_ROW_82_1117 vccd1 vssd1 X2_sky130_fd_sc_hd__tapvpwrvgnd_1
XFILLER_45_385 vssd1 vccd1 vccd1 vssd1 X2_sky130_fd_sc_hd__fill_4
X_517_ vccd1 vssd1 vccd1 vssd1 _517_/Y _517_/A X2_sky130_fd_sc_hd__inv_2
XFILLER_72_193 vssd1 vccd1 vccd1 vssd1 X2_sky130_fd_sc_hd__fill_2
XFILLER_54_81 vssd1 vccd1 vccd1 vssd1 X2_sky130_fd_sc_hd__fill_2
X_448_ vccd1 vssd1 vccd1 vssd1 hold36/X _587_/D _448_/A1 _440_/Y X2_sky130_fd_sc_hd__a21boi_1
XFILLER_60_377 vssd1 vccd1 vssd1 vccd1 X2_sky130_ef_sc_hd__decap_40_12
XFILLER_13_293 vssd1 vccd1 vssd1 vccd1 X2_sky130_ef_sc_hd__decap_40_12
X_379_ _362_/X _393_/C _379_/X _379_/C vssd1 vccd1 vccd1 vssd1 X2_sky130_fd_sc_hd__and3b_1
XFILLER_55_3 vssd1 vccd1 vssd1 vccd1 X2_sky130_ef_sc_hd__decap_40_12
XTAP_TAPCELL_ROW_93_1246 vccd1 vssd1 X2_sky130_fd_sc_hd__tapvpwrvgnd_1
XANTENNA__498__A _517_/A vssd1 vccd1 vccd1 vssd1 X2_sky130_fd_sc_hd__diode_2
XFILLER_68_433 vssd1 vccd1 vssd1 vccd1 X2_sky130_ef_sc_hd__decap_40_12
XFILLER_68_477 vssd1 vccd1 vssd1 vccd1 X2_sky130_ef_sc_hd__decap_40_12
XFILLER_55_105 vssd1 vccd1 vccd1 vssd1 X2_sky130_fd_sc_hd__fill_4
XFILLER_83_447 vccd1 vssd1 vccd1 vssd1 X2_sky130_fd_sc_hd__fill_1
XFILLER_55_149 vssd1 vccd1 vssd1 vccd1 X2_sky130_ef_sc_hd__decap_40_12
XTAP_TAPCELL_ROW_26_509 vccd1 vssd1 X2_sky130_fd_sc_hd__tapvpwrvgnd_1
XFILLER_36_363 vccd1 vssd1 vccd1 vssd1 X2_sky130_fd_sc_hd__fill_1
XFILLER_71_609 vssd1 vccd1 vccd1 vssd1 X2_sky130_fd_sc_hd__fill_4
XTAP_TAPCELL_ROW_54_818 vccd1 vssd1 X2_sky130_fd_sc_hd__tapvpwrvgnd_1
XFILLER_24_525 vssd1 vccd1 vccd1 vssd1 X2_sky130_fd_sc_hd__fill_4
XFILLER_24_569 vssd1 vccd1 vssd1 vccd1 X2_sky130_ef_sc_hd__decap_40_12
XFILLER_34_29 vssd1 vccd1 vssd1 vccd1 X2_sky130_ef_sc_hd__decap_40_12
XFILLER_63_193 vssd1 vccd1 vccd1 vssd1 X2_sky130_fd_sc_hd__fill_2
XFILLER_51_333 vssd1 vccd1 vccd1 vssd1 X2_sky130_fd_sc_hd__fill_2
XTAP_TAPCELL_ROW_34_597 vccd1 vssd1 X2_sky130_fd_sc_hd__tapvpwrvgnd_1
Xclkload6 vssd1 vccd1 vssd1 vccd1 _606_/CLK clkload6/Y X2_sky130_fd_sc_hd__bufinv_16
XFILLER_3_429 vssd1 vccd1 vssd1 vccd1 X2_sky130_ef_sc_hd__decap_40_12
XFILLER_59_15 vssd1 vccd1 vssd1 vccd1 X2_sky130_ef_sc_hd__decap_40_12
XFILLER_101_541 vccd1 vssd1 vccd1 vssd1 X2_sky130_fd_sc_hd__fill_1
XTAP_TAPCELL_ROW_6_289 vccd1 vssd1 X2_sky130_fd_sc_hd__tapvpwrvgnd_1
XFILLER_101_585 vssd1 vccd1 vccd1 vssd1 X2_sky130_fd_sc_hd__fill_2
XFILLER_47_617 vssd1 vccd1 vccd1 vssd1 X2_sky130_fd_sc_hd__fill_4
XANTENNA_fanout62_A input13/X vssd1 vccd1 vccd1 vssd1 X2_sky130_fd_sc_hd__diode_2
XFILLER_75_69 vssd1 vccd1 vssd1 vccd1 X2_sky130_ef_sc_hd__decap_40_12
XFILLER_15_503 vccd1 vssd1 vccd1 vssd1 X2_sky130_fd_sc_hd__fill_1
XFILLER_74_469 vssd1 vccd1 vccd1 vssd1 X2_sky130_fd_sc_hd__fill_4
XFILLER_62_609 vssd1 vccd1 vccd1 vssd1 X2_sky130_fd_sc_hd__fill_2
XFILLER_27_385 vssd1 vccd1 vccd1 vssd1 X2_sky130_fd_sc_hd__fill_4
XFILLER_91_57 vssd1 vccd1 vssd1 vccd1 X2_sky130_ef_sc_hd__decap_40_12
XFILLER_54_193 vssd1 vccd1 vccd1 vssd1 X2_sky130_fd_sc_hd__fill_2
XFILLER_42_355 vssd1 vccd1 vccd1 vssd1 X2_sky130_fd_sc_hd__fill_2
X_302_ vccd1 vssd1 vssd1 vccd1 _303_/A _303_/B _317_/B X2_sky130_fd_sc_hd__nor2_8
XFILLER_42_399 vssd1 vccd1 vccd1 vssd1 X2_sky130_fd_sc_hd__fill_4
XFILLER_6_245 vssd1 vccd1 vccd1 vssd1 X2_sky130_fd_sc_hd__fill_4
XFILLER_6_289 vssd1 vccd1 vssd1 vccd1 X2_sky130_ef_sc_hd__decap_40_12
XFILLER_40_83 vccd1 vssd1 vccd1 vssd1 X2_sky130_fd_sc_hd__fill_1
XTAP_TAPCELL_ROW_79_1090 vccd1 vssd1 X2_sky130_fd_sc_hd__tapvpwrvgnd_1
XFILLER_97_517 vssd1 vccd1 vssd1 vccd1 X2_sky130_ef_sc_hd__decap_40_12
XFILLER_2_473 vssd1 vccd1 vccd1 vssd1 X2_sky130_fd_sc_hd__fill_2
XFILLER_49_81 vssd1 vccd1 vssd1 vccd1 X2_sky130_ef_sc_hd__decap_40_12
XFILLER_37_105 vssd1 vccd1 vccd1 vssd1 X2_sky130_fd_sc_hd__fill_4
XFILLER_1_55 vccd1 vssd1 vccd1 vssd1 X2_sky130_fd_sc_hd__fill_1
XFILLER_92_233 vssd1 vccd1 vssd1 vccd1 X2_sky130_ef_sc_hd__decap_40_12
XFILLER_65_447 vccd1 vssd1 vccd1 vssd1 X2_sky130_fd_sc_hd__fill_1
XFILLER_37_149 vssd1 vccd1 vssd1 vccd1 X2_sky130_ef_sc_hd__decap_40_12
XFILLER_18_363 vccd1 vssd1 vccd1 vssd1 X2_sky130_fd_sc_hd__fill_1
XFILLER_33_311 vssd1 vccd1 vccd1 vssd1 X2_sky130_fd_sc_hd__fill_8
XFILLER_80_417 vssd1 vccd1 vccd1 vssd1 X2_sky130_fd_sc_hd__fill_2
XFILLER_33_322 vssd1 vccd1 vssd1 vccd1 X2_sky130_ef_sc_hd__decap_40_12
XFILLER_45_193 vssd1 vccd1 vccd1 vssd1 X2_sky130_fd_sc_hd__fill_4
XFILLER_21_517 vssd1 vccd1 vssd1 vccd1 X2_sky130_ef_sc_hd__decap_40_12
XFILLER_60_141 vssd1 vccd1 vssd1 vccd1 X2_sky130_ef_sc_hd__decap_40_12
XTAP_TAPCELL_ROW_31_556 vccd1 vssd1 X2_sky130_fd_sc_hd__tapvpwrvgnd_1
Xhold18 _562_/D _328_/X vccd1 vssd1 vssd1 vccd1 X2_sky130_fd_sc_hd__dlygate4sd3_1
Xhold29 _565_/D _318_/X vccd1 vssd1 vssd1 vccd1 X2_sky130_fd_sc_hd__dlygate4sd3_1
XFILLER_29_617 vssd1 vccd1 vccd1 vssd1 X2_sky130_fd_sc_hd__fill_4
XTAP_TAPCELL_ROW_3_248 vccd1 vssd1 X2_sky130_fd_sc_hd__tapvpwrvgnd_1
XTAP_TAPCELL_ROW_39_645 vccd1 vssd1 X2_sky130_fd_sc_hd__tapvpwrvgnd_1
XTAP_TAPCELL_ROW_67_954 vccd1 vssd1 X2_sky130_fd_sc_hd__tapvpwrvgnd_1
XFILLER_56_469 vssd1 vccd1 vccd1 vssd1 X2_sky130_fd_sc_hd__fill_4
XFILLER_71_417 vssd1 vccd1 vssd1 vccd1 X2_sky130_ef_sc_hd__decap_40_12
XFILLER_45_39 vssd1 vccd1 vssd1 vccd1 X2_sky130_ef_sc_hd__decap_40_12
XFILLER_24_333 vssd1 vccd1 vssd1 vccd1 X2_sky130_ef_sc_hd__decap_40_12
XFILLER_36_193 vssd1 vccd1 vccd1 vssd1 X2_sky130_fd_sc_hd__fill_2
XFILLER_24_377 vssd1 vccd1 vssd1 vccd1 X2_sky130_ef_sc_hd__decap_40_12
XFILLER_61_27 vssd1 vccd1 vssd1 vccd1 X2_sky130_ef_sc_hd__decap_40_12
XFILLER_3_237 vssd1 vccd1 vssd1 vccd1 X2_sky130_ef_sc_hd__decap_40_12
XFILLER_10_53 vssd1 vccd1 vssd1 vccd1 X2_sky130_ef_sc_hd__decap_40_12
XFILLER_10_97 vssd1 vccd1 vssd1 vccd1 X2_sky130_ef_sc_hd__decap_40_12
XFILLER_79_517 vssd1 vccd1 vssd1 vccd1 X2_sky130_ef_sc_hd__decap_40_12
XFILLER_19_105 vssd1 vccd1 vccd1 vssd1 X2_sky130_fd_sc_hd__fill_4
XFILLER_87_561 vssd1 vccd1 vssd1 vccd1 X2_sky130_ef_sc_hd__decap_40_12
XFILLER_101_360 vssd1 vccd1 vccd1 vssd1 X2_sky130_fd_sc_hd__fill_4
XFILLER_19_51 vssd1 vccd1 vccd1 vssd1 X2_sky130_fd_sc_hd__fill_4
XANTENNA_fanout65_X _525_/A vssd1 vccd1 vccd1 vssd1 X2_sky130_fd_sc_hd__diode_2
XFILLER_101_393 vssd1 vccd1 vccd1 vssd1 X2_sky130_fd_sc_hd__fill_8
XFILLER_47_436 vssd1 vccd1 vccd1 vssd1 X2_sky130_fd_sc_hd__fill_2
XFILLER_19_149 vssd1 vccd1 vssd1 vccd1 X2_sky130_ef_sc_hd__decap_40_12
XFILLER_74_233 vssd1 vccd1 vssd1 vccd1 X2_sky130_ef_sc_hd__decap_40_12
XFILLER_74_277 vssd1 vccd1 vssd1 vccd1 X2_sky130_ef_sc_hd__decap_40_12
XFILLER_62_417 vssd1 vccd1 vccd1 vssd1 X2_sky130_fd_sc_hd__fill_2
XFILLER_15_333 vssd1 vccd1 vccd1 vssd1 X2_sky130_fd_sc_hd__fill_2
XFILLER_27_193 vssd1 vccd1 vssd1 vccd1 X2_sky130_ef_sc_hd__decap_40_12
XFILLER_42_141 vssd1 vccd1 vssd1 vccd1 X2_sky130_ef_sc_hd__decap_40_12
XFILLER_11_561 vssd1 vccd1 vssd1 vccd1 X2_sky130_ef_sc_hd__decap_40_12
XANTENNA_clkbuf_3_7__f_wb_clk_i_A clkbuf_0_wb_clk_i/X vssd1 vccd1 vccd1 vssd1 X2_sky130_fd_sc_hd__diode_2
XFILLER_51_93 vssd1 vccd1 vssd1 vccd1 X2_sky130_ef_sc_hd__decap_40_12
XTAP_TAPCELL_ROW_90_1205 vccd1 vssd1 X2_sky130_fd_sc_hd__tapvpwrvgnd_1
XANTENNA__571__CLK _606_/CLK vssd1 vccd1 vccd1 vssd1 X2_sky130_fd_sc_hd__diode_2
XFILLER_18_3 vssd1 vccd1 vssd1 vccd1 X2_sky130_ef_sc_hd__decap_40_12
XTAP_TAPCELL_ROW_0_207 vccd1 vssd1 X2_sky130_fd_sc_hd__tapvpwrvgnd_1
XTAP_TAPCELL_ROW_0_218 vccd1 vssd1 X2_sky130_fd_sc_hd__tapvpwrvgnd_1
XFILLER_93_553 vssd1 vccd1 vccd1 vssd1 X2_sky130_fd_sc_hd__fill_4
XTAP_TAPCELL_ROW_36_615 vccd1 vssd1 X2_sky130_fd_sc_hd__tapvpwrvgnd_1
XTAP_TAPCELL_ROW_88_1189 vccd1 vssd1 X2_sky130_fd_sc_hd__tapvpwrvgnd_1
XFILLER_93_597 vssd1 vccd1 vssd1 vccd1 X2_sky130_ef_sc_hd__decap_40_12
XTAP_TAPCELL_ROW_64_924 vccd1 vssd1 X2_sky130_fd_sc_hd__tapvpwrvgnd_1
XFILLER_18_193 vssd1 vccd1 vccd1 vssd1 X2_sky130_fd_sc_hd__fill_2
XFILLER_61_461 vssd1 vccd1 vssd1 vccd1 X2_sky130_ef_sc_hd__decap_40_12
XTAP_TAPCELL_ROW_16_394 vccd1 vssd1 X2_sky130_fd_sc_hd__tapvpwrvgnd_1
XTAP_TAPCELL_ROW_8_307 vccd1 vssd1 X2_sky130_fd_sc_hd__tapvpwrvgnd_1
XANTENNA__303__X _303_/X vssd1 vccd1 vccd1 vssd1 X2_sky130_fd_sc_hd__diode_2
XFILLER_69_561 vssd1 vccd1 vccd1 vssd1 X2_sky130_fd_sc_hd__fill_4
XFILLER_84_531 vccd1 vssd1 vccd1 vssd1 X2_sky130_fd_sc_hd__fill_1
XFILLER_56_27 vccd1 vssd1 vccd1 vssd1 X2_sky130_fd_sc_hd__fill_1
XFILLER_17_609 vssd1 vccd1 vccd1 vssd1 X2_sky130_fd_sc_hd__fill_4
XFILLER_29_447 vccd1 vssd1 vccd1 vssd1 X2_sky130_fd_sc_hd__fill_1
XFILLER_56_233 vssd1 vccd1 vssd1 vccd1 X2_sky130_ef_sc_hd__decap_40_12
XFILLER_72_15 vssd1 vccd1 vssd1 vccd1 X2_sky130_ef_sc_hd__decap_40_12
XFILLER_71_225 vssd1 vccd1 vssd1 vccd1 X2_sky130_ef_sc_hd__decap_40_12
XFILLER_24_141 vssd1 vccd1 vssd1 vccd1 X2_sky130_ef_sc_hd__decap_40_12
XFILLER_40_601 vssd1 vccd1 vccd1 vssd1 X2_sky130_fd_sc_hd__fill_8
XFILLER_52_472 vssd1 vccd1 vccd1 vssd1 X2_sky130_fd_sc_hd__fill_4
XFILLER_8_307 vccd1 vssd1 vccd1 vssd1 X2_sky130_fd_sc_hd__fill_1
XFILLER_4_513 vssd1 vccd1 vssd1 vccd1 X2_sky130_ef_sc_hd__decap_40_12
XFILLER_4_557 vssd1 vccd1 vssd1 vccd1 X2_sky130_ef_sc_hd__decap_40_12
XTAP_TAPCELL_ROW_76_1060 vccd1 vssd1 X2_sky130_fd_sc_hd__tapvpwrvgnd_1
XFILLER_75_553 vssd1 vccd1 vccd1 vssd1 X2_sky130_fd_sc_hd__fill_4
XFILLER_47_244 vssd1 vccd1 vccd1 vssd1 X2_sky130_fd_sc_hd__fill_2
XFILLER_35_417 vssd1 vccd1 vssd1 vccd1 X2_sky130_ef_sc_hd__decap_40_12
XFILLER_90_501 vssd1 vccd1 vssd1 vccd1 X2_sky130_ef_sc_hd__decap_40_12
XFILLER_35_439 vccd1 vssd1 vccd1 vssd1 X2_sky130_fd_sc_hd__fill_1
XFILLER_90_545 vssd1 vccd1 vssd1 vccd1 X2_sky130_ef_sc_hd__decap_40_12
XFILLER_62_225 vssd1 vccd1 vssd1 vccd1 X2_sky130_ef_sc_hd__decap_40_12
XFILLER_90_589 vssd1 vccd1 vssd1 vccd1 X2_sky130_ef_sc_hd__decap_40_12
XFILLER_43_461 vssd1 vccd1 vccd1 vssd1 X2_sky130_fd_sc_hd__fill_2
XFILLER_43_483 vssd1 vccd1 vccd1 vssd1 X2_sky130_fd_sc_hd__fill_2
XFILLER_30_133 vssd1 vccd1 vccd1 vssd1 X2_sky130_fd_sc_hd__fill_4
XFILLER_62_81 vssd1 vccd1 vccd1 vssd1 X2_sky130_fd_sc_hd__fill_2
XTAP_TAPCELL_ROW_13_364 vccd1 vssd1 X2_sky130_fd_sc_hd__tapvpwrvgnd_1
XFILLER_30_177 vssd1 vccd1 vssd1 vccd1 X2_sky130_ef_sc_hd__decap_40_12
XTAP_TAPCELL_ROW_41_673 vccd1 vssd1 X2_sky130_fd_sc_hd__tapvpwrvgnd_1
XFILLER_11_391 vccd1 vssd1 vccd1 vssd1 X2_sky130_fd_sc_hd__fill_1
XFILLER_7_373 vssd1 vccd1 vssd1 vccd1 X2_sky130_ef_sc_hd__decap_40_12
XFILLER_98_601 vssd1 vccd1 vssd1 vccd1 X2_sky130_ef_sc_hd__decap_40_12
XFILLER_97_111 vccd1 vssd1 vccd1 vssd1 X2_sky130_fd_sc_hd__fill_1
XFILLER_85_317 vssd1 vccd1 vccd1 vssd1 X2_sky130_fd_sc_hd__fill_4
XFILLER_85_328 vssd1 vccd1 vccd1 vssd1 X2_sky130_fd_sc_hd__fill_2
XFILLER_38_233 vssd1 vccd1 vssd1 vccd1 X2_sky130_ef_sc_hd__decap_40_12
XFILLER_66_531 vccd1 vssd1 vccd1 vssd1 X2_sky130_fd_sc_hd__fill_1
XFILLER_26_417 vssd1 vccd1 vccd1 vssd1 X2_sky130_fd_sc_hd__fill_2
XFILLER_81_501 vssd1 vccd1 vccd1 vssd1 X2_sky130_fd_sc_hd__fill_2
XTAP_TAPCELL_ROW_49_762 vccd1 vssd1 X2_sky130_fd_sc_hd__tapvpwrvgnd_1
XFILLER_53_225 vssd1 vccd1 vssd1 vccd1 X2_sky130_ef_sc_hd__decap_40_12
XFILLER_22_601 vssd1 vccd1 vssd1 vccd1 X2_sky130_ef_sc_hd__decap_40_12
XFILLER_34_450 vssd1 vccd1 vccd1 vssd1 X2_sky130_fd_sc_hd__fill_4
XFILLER_21_111 vccd1 vssd1 vccd1 vssd1 X2_sky130_fd_sc_hd__fill_1
XFILLER_42_29 vssd1 vccd1 vssd1 vccd1 X2_sky130_ef_sc_hd__decap_40_12
XFILLER_1_505 vssd1 vccd1 vssd1 vccd1 X2_sky130_ef_sc_hd__decap_40_12
XANTENNA_clkbuf_3_6__f_wb_clk_i_X _607_/CLK vssd1 vccd1 vccd1 vssd1 X2_sky130_fd_sc_hd__diode_2
XFILLER_88_133 vssd1 vccd1 vccd1 vssd1 X2_sky130_fd_sc_hd__fill_4
XFILLER_76_306 vssd1 vccd1 vccd1 vssd1 X2_sky130_fd_sc_hd__fill_2
XFILLER_88_177 vssd1 vccd1 vssd1 vccd1 X2_sky130_ef_sc_hd__decap_40_12
XFILLER_69_391 vccd1 vssd1 vccd1 vssd1 X2_sky130_fd_sc_hd__fill_1
XFILLER_57_553 vssd1 vccd1 vccd1 vssd1 X2_sky130_fd_sc_hd__fill_4
XFILLER_17_417 vssd1 vccd1 vssd1 vccd1 X2_sky130_ef_sc_hd__decap_40_12
X_550_ vssd1 vccd1 vccd1 vssd1 _553_/CLK _550_/D _470_/Y _550_/Q X2_sky130_fd_sc_hd__dfrtp_1
XFILLER_84_361 vssd1 vccd1 vccd1 vssd1 X2_sky130_fd_sc_hd__fill_2
XFILLER_72_501 vssd1 vccd1 vssd1 vccd1 X2_sky130_ef_sc_hd__decap_40_12
XFILLER_57_586 vssd1 vccd1 vssd1 vccd1 X2_sky130_ef_sc_hd__decap_40_12
XFILLER_44_214 vssd1 vccd1 vssd1 vccd1 X2_sky130_ef_sc_hd__decap_40_12
XFILLER_83_69 vssd1 vccd1 vssd1 vccd1 X2_sky130_ef_sc_hd__decap_40_12
XFILLER_72_545 vssd1 vccd1 vssd1 vccd1 X2_sky130_ef_sc_hd__decap_40_12
XFILLER_16_41 vssd1 vccd1 vssd1 vccd1 X2_sky130_ef_sc_hd__decap_40_12
XFILLER_25_461 vssd1 vccd1 vssd1 vccd1 X2_sky130_ef_sc_hd__decap_40_12
X_481_ vccd1 vssd1 vccd1 vssd1 _481_/Y _517_/A X2_sky130_fd_sc_hd__inv_2
XFILLER_72_589 vssd1 vccd1 vccd1 vssd1 X2_sky130_fd_sc_hd__fill_4
XPHY_EDGE_ROW_11_Right_11 vccd1 vssd1 vccd1 vssd1 X2_sky130_fd_sc_hd__decap_3
XFILLER_16_85 vssd1 vccd1 vssd1 vccd1 X2_sky130_ef_sc_hd__decap_40_12
XFILLER_12_133 vssd1 vccd1 vccd1 vssd1 X2_sky130_fd_sc_hd__fill_4
XFILLER_12_177 vssd1 vccd1 vssd1 vccd1 X2_sky130_ef_sc_hd__decap_40_12
XFILLER_40_475 vccd1 vssd1 vccd1 vssd1 X2_sky130_fd_sc_hd__fill_1
XFILLER_8_137 vssd1 vccd1 vccd1 vssd1 X2_sky130_fd_sc_hd__fill_2
XTAP_TAPCELL_ROW_10_334 vccd1 vssd1 X2_sky130_fd_sc_hd__tapvpwrvgnd_1
XFILLER_4_321 vssd1 vccd1 vssd1 vccd1 X2_sky130_ef_sc_hd__decap_40_12
XFILLER_4_365 vssd1 vccd1 vssd1 vccd1 X2_sky130_ef_sc_hd__decap_40_12
XPHY_EDGE_ROW_20_Right_20 vccd1 vssd1 vccd1 vssd1 X2_sky130_fd_sc_hd__decap_3
XFILLER_79_111 vccd1 vssd1 vccd1 vssd1 X2_sky130_fd_sc_hd__fill_1
XFILLER_95_615 vccd1 vssd1 vccd1 vssd1 X2_sky130_fd_sc_hd__fill_1
XFILLER_82_309 vssd1 vccd1 vssd1 vccd1 X2_sky130_ef_sc_hd__decap_40_12
XFILLER_75_361 vssd1 vccd1 vssd1 vccd1 X2_sky130_ef_sc_hd__decap_40_12
XFILLER_63_501 vssd1 vccd1 vccd1 vssd1 X2_sky130_fd_sc_hd__fill_2
XFILLER_57_81 vssd1 vccd1 vssd1 vccd1 X2_sky130_ef_sc_hd__decap_40_12
XTAP_TAPCELL_ROW_18_423 vccd1 vssd1 X2_sky130_fd_sc_hd__tapvpwrvgnd_1
XFILLER_35_225 vssd1 vccd1 vssd1 vccd1 X2_sky130_ef_sc_hd__decap_40_12
XTAP_TAPCELL_ROW_46_721 vccd1 vssd1 X2_sky130_fd_sc_hd__tapvpwrvgnd_1
XTAP_TAPCELL_ROW_85_1159 vccd1 vssd1 X2_sky130_fd_sc_hd__tapvpwrvgnd_1
XFILLER_50_206 vssd1 vccd1 vssd1 vccd1 X2_sky130_ef_sc_hd__decap_40_12
XFILLER_85_3 vssd1 vccd1 vssd1 vccd1 X2_sky130_ef_sc_hd__decap_40_12
XANTENNA__319__B2 _537_/Q vssd1 vccd1 vccd1 vssd1 X2_sky130_fd_sc_hd__diode_2
XFILLER_31_497 vssd1 vccd1 vccd1 vssd1 X2_sky130_fd_sc_hd__fill_4
XFILLER_7_181 vssd1 vccd1 vssd1 vccd1 X2_sky130_ef_sc_hd__decap_40_12
XTAP_TAPCELL_ROW_96_1277 vccd1 vssd1 X2_sky130_fd_sc_hd__tapvpwrvgnd_1
XFILLER_98_475 vccd1 vssd1 vccd1 vssd1 X2_sky130_fd_sc_hd__fill_1
XFILLER_85_125 vssd1 vccd1 vssd1 vccd1 X2_sky130_ef_sc_hd__decap_40_12
XFILLER_58_328 vccd1 vssd1 vccd1 vssd1 X2_sky130_fd_sc_hd__fill_1
XFILLER_100_469 vssd1 vccd1 vccd1 vssd1 X2_sky130_fd_sc_hd__fill_4
XFILLER_85_169 vssd1 vccd1 vssd1 vccd1 X2_sky130_ef_sc_hd__decap_40_12
XFILLER_66_361 vssd1 vccd1 vccd1 vssd1 X2_sky130_fd_sc_hd__fill_2
XFILLER_39_597 vssd1 vccd1 vccd1 vssd1 X2_sky130_fd_sc_hd__fill_8
XFILLER_54_589 vssd1 vccd1 vssd1 vccd1 X2_sky130_ef_sc_hd__decap_40_12
XFILLER_53_39 vssd1 vccd1 vssd1 vccd1 X2_sky130_ef_sc_hd__decap_40_12
XFILLER_22_475 vccd1 vssd1 vccd1 vssd1 X2_sky130_fd_sc_hd__fill_1
XFILLER_1_335 vccd1 vssd1 vccd1 vssd1 X2_sky130_fd_sc_hd__fill_1
XFILLER_77_615 vccd1 vssd1 vccd1 vssd1 X2_sky130_fd_sc_hd__fill_1
XFILLER_89_497 vssd1 vccd1 vccd1 vssd1 X2_sky130_fd_sc_hd__fill_4
XFILLER_49_317 vssd1 vccd1 vssd1 vccd1 X2_sky130_ef_sc_hd__decap_40_12
X_602_ vssd1 vccd1 vccd1 vssd1 _607_/CLK _602_/D _522_/Y _602_/Q X2_sky130_fd_sc_hd__dfrtp_1
XFILLER_64_309 vccd1 vssd1 vccd1 vssd1 X2_sky130_fd_sc_hd__fill_1
XFILLER_45_501 vssd1 vccd1 vccd1 vssd1 X2_sky130_fd_sc_hd__fill_2
XFILLER_17_225 vssd1 vccd1 vssd1 vccd1 X2_sky130_ef_sc_hd__decap_40_12
XFILLER_27_51 vssd1 vccd1 vccd1 vssd1 X2_sky130_fd_sc_hd__fill_4
XFILLER_45_545 vssd1 vccd1 vccd1 vssd1 X2_sky130_fd_sc_hd__fill_4
X_533_ vssd1 vccd1 vccd1 vssd1 _553_/CLK _533_/D _453_/Y hold4/A X2_sky130_fd_sc_hd__dfrtp_2
X_464_ vccd1 vssd1 vccd1 vssd1 _464_/Y _527_/A X2_sky130_fd_sc_hd__inv_2
XFILLER_40_250 vssd1 vccd1 vccd1 vssd1 X2_sky130_fd_sc_hd__fill_2
X_395_ vccd1 vssd1 _395_/X _392_/C _389_/B _390_/A _387_/X vssd1 vccd1 X2_sky130_fd_sc_hd__a31o_1
XFILLER_13_497 vssd1 vccd1 vccd1 vssd1 X2_sky130_fd_sc_hd__fill_4
XTAP_TAPCELL_ROW_23_470 vccd1 vssd1 X2_sky130_fd_sc_hd__tapvpwrvgnd_1
XFILLER_99_217 vssd1 vccd1 vccd1 vssd1 X2_sky130_fd_sc_hd__fill_4
XFILLER_4_77 vssd1 vccd1 vccd1 vssd1 X2_sky130_fd_sc_hd__fill_4
XFILLER_4_195 vccd1 vssd1 vccd1 vssd1 X2_sky130_fd_sc_hd__fill_1
XFILLER_95_445 vssd1 vccd1 vccd1 vssd1 X2_sky130_fd_sc_hd__fill_2
XFILLER_67_125 vssd1 vccd1 vssd1 vccd1 X2_sky130_ef_sc_hd__decap_40_12
XFILLER_67_169 vssd1 vccd1 vssd1 vccd1 X2_sky130_ef_sc_hd__decap_40_12
XFILLER_48_361 vssd1 vccd1 vccd1 vssd1 X2_sky130_fd_sc_hd__fill_2
XFILLER_36_545 vssd1 vccd1 vccd1 vssd1 X2_sky130_fd_sc_hd__fill_4
XFILLER_82_139 vccd1 vssd1 vccd1 vssd1 X2_sky130_fd_sc_hd__fill_1
XFILLER_23_217 vssd1 vccd1 vccd1 vssd1 X2_sky130_fd_sc_hd__fill_4
XFILLER_36_589 vccd1 vssd1 vccd1 vssd1 X2_sky130_fd_sc_hd__fill_1
XFILLER_51_559 vccd1 vssd1 vccd1 vssd1 X2_sky130_fd_sc_hd__fill_1
XFILLER_31_261 vssd1 vccd1 vssd1 vccd1 X2_sky130_ef_sc_hd__decap_40_12
XFILLER_86_401 vssd1 vccd1 vssd1 vccd1 X2_sky130_ef_sc_hd__decap_40_12
XFILLER_59_615 vccd1 vssd1 vccd1 vssd1 X2_sky130_fd_sc_hd__fill_1
XANTENNA__362__A_N _534_/Q vssd1 vccd1 vccd1 vssd1 X2_sky130_fd_sc_hd__diode_2
XFILLER_100_233 vssd1 vccd1 vssd1 vccd1 X2_sky130_ef_sc_hd__decap_40_12
XFILLER_86_445 vssd1 vccd1 vssd1 vccd1 X2_sky130_ef_sc_hd__decap_40_12
XFILLER_27_501 vssd1 vccd1 vccd1 vssd1 X2_sky130_fd_sc_hd__fill_2
XFILLER_100_277 vssd1 vccd1 vssd1 vccd1 X2_sky130_ef_sc_hd__decap_40_12
XFILLER_86_489 vssd1 vccd1 vssd1 vccd1 X2_sky130_ef_sc_hd__decap_40_12
XFILLER_46_309 vccd1 vssd1 vccd1 vssd1 X2_sky130_fd_sc_hd__fill_1
XFILLER_64_27 vccd1 vssd1 vccd1 vssd1 X2_sky130_fd_sc_hd__fill_1
XTAP_TAPCELL_ROW_57_849 vccd1 vssd1 X2_sky130_fd_sc_hd__tapvpwrvgnd_1
XFILLER_81_161 vssd1 vccd1 vccd1 vssd1 X2_sky130_fd_sc_hd__fill_4
XFILLER_42_537 vssd1 vccd1 vccd1 vssd1 X2_sky130_fd_sc_hd__fill_2
XFILLER_10_401 vssd1 vccd1 vssd1 vccd1 X2_sky130_ef_sc_hd__decap_40_12
Xfanout65 vccd1 vssd1 _525_/A input13/X vccd1 vssd1 X2_sky130_fd_sc_hd__buf_4
XFILLER_80_15 vssd1 vccd1 vssd1 vccd1 X2_sky130_ef_sc_hd__decap_40_12
XFILLER_10_445 vssd1 vccd1 vssd1 vccd1 X2_sky130_ef_sc_hd__decap_40_12
XTAP_TAPCELL_ROW_20_440 vccd1 vssd1 X2_sky130_fd_sc_hd__tapvpwrvgnd_1
XFILLER_10_489 vssd1 vccd1 vssd1 vccd1 X2_sky130_ef_sc_hd__decap_40_12
XFILLER_89_57 vssd1 vccd1 vssd1 vccd1 X2_sky130_ef_sc_hd__decap_40_12
XPHY_EDGE_ROW_8_Left_110 vccd1 vssd1 vccd1 vssd1 X2_sky130_fd_sc_hd__decap_3
XFILLER_96_209 vssd1 vccd1 vssd1 vccd1 X2_sky130_ef_sc_hd__decap_40_12
XFILLER_1_165 vssd1 vccd1 vccd1 vssd1 X2_sky130_fd_sc_hd__fill_2
XFILLER_89_261 vssd1 vccd1 vssd1 vccd1 X2_sky130_ef_sc_hd__decap_40_12
XFILLER_77_445 vssd1 vccd1 vccd1 vssd1 X2_sky130_fd_sc_hd__fill_2
XFILLER_49_125 vssd1 vccd1 vssd1 vccd1 X2_sky130_ef_sc_hd__decap_40_12
XFILLER_18_501 vssd1 vccd1 vssd1 vccd1 X2_sky130_ef_sc_hd__decap_40_12
XFILLER_49_169 vssd1 vccd1 vssd1 vccd1 X2_sky130_ef_sc_hd__decap_40_12
XFILLER_38_83 vccd1 vssd1 vccd1 vssd1 X2_sky130_fd_sc_hd__fill_1
XFILLER_64_139 vccd1 vssd1 vccd1 vssd1 X2_sky130_fd_sc_hd__fill_1
XFILLER_18_545 vssd1 vccd1 vssd1 vccd1 X2_sky130_ef_sc_hd__decap_40_12
XFILLER_18_589 vssd1 vccd1 vssd1 vccd1 X2_sky130_ef_sc_hd__decap_40_12
X_516_ vccd1 vssd1 vccd1 vssd1 _516_/Y _527_/A X2_sky130_fd_sc_hd__inv_2
XFILLER_33_526 vssd1 vccd1 vccd1 vssd1 X2_sky130_fd_sc_hd__fill_2
XTAP_TAPCELL_ROW_82_1118 vccd1 vssd1 X2_sky130_fd_sc_hd__tapvpwrvgnd_1
XFILLER_60_301 vssd1 vccd1 vccd1 vssd1 X2_sky130_fd_sc_hd__fill_4
XFILLER_33_559 vccd1 vssd1 vccd1 vssd1 X2_sky130_fd_sc_hd__fill_1
XFILLER_60_345 vssd1 vccd1 vccd1 vssd1 X2_sky130_fd_sc_hd__fill_2
XFILLER_13_261 vssd1 vccd1 vssd1 vccd1 X2_sky130_ef_sc_hd__decap_40_12
XFILLER_20_209 vssd1 vccd1 vssd1 vccd1 X2_sky130_ef_sc_hd__decap_40_12
X_447_ vccd1 vssd1 vccd1 vssd1 hold47/X _586_/D _447_/A1 _440_/Y X2_sky130_fd_sc_hd__a21boi_1
XFILLER_60_389 vssd1 vccd1 vssd1 vccd1 X2_sky130_ef_sc_hd__decap_40_12
XFILLER_9_221 vssd1 vccd1 vccd1 vssd1 X2_sky130_fd_sc_hd__fill_2
X_378_ _378_/X _362_/X _379_/C _377_/B _393_/C vccd1 vssd1 vssd1 vccd1 X2_sky130_fd_sc_hd__o31a_1
XFILLER_70_81 vssd1 vccd1 vccd1 vssd1 X2_sky130_fd_sc_hd__fill_2
XTAP_TAPCELL_ROW_93_1247 vccd1 vssd1 X2_sky130_fd_sc_hd__tapvpwrvgnd_1
XFILLER_48_3 vssd1 vccd1 vssd1 vccd1 X2_sky130_ef_sc_hd__decap_40_12
XFILLER_68_401 vssd1 vccd1 vssd1 vccd1 X2_sky130_ef_sc_hd__decap_40_12
XFILLER_68_445 vssd1 vccd1 vssd1 vccd1 X2_sky130_ef_sc_hd__decap_40_12
XFILLER_28_309 vssd1 vccd1 vssd1 vccd1 X2_sky130_ef_sc_hd__decap_40_12
XFILLER_68_489 vssd1 vccd1 vssd1 vccd1 X2_sky130_ef_sc_hd__decap_40_12
XFILLER_56_618 vssd1 vccd1 vccd1 vssd1 X2_sky130_fd_sc_hd__fill_2
XTAP_TAPCELL_ROW_54_819 vccd1 vssd1 X2_sky130_fd_sc_hd__tapvpwrvgnd_1
XFILLER_70_109 vssd1 vccd1 vssd1 vccd1 X2_sky130_ef_sc_hd__decap_40_12
XFILLER_63_161 vssd1 vccd1 vccd1 vssd1 X2_sky130_fd_sc_hd__fill_4
XFILLER_36_397 vssd1 vccd1 vccd1 vssd1 X2_sky130_fd_sc_hd__fill_2
XFILLER_51_389 vssd1 vccd1 vccd1 vssd1 X2_sky130_fd_sc_hd__fill_2
XFILLER_32_592 vssd1 vccd1 vccd1 vssd1 X2_sky130_fd_sc_hd__fill_2
XTAP_TAPCELL_ROW_34_598 vccd1 vssd1 X2_sky130_fd_sc_hd__tapvpwrvgnd_1
XFILLER_50_29 vssd1 vccd1 vssd1 vccd1 X2_sky130_ef_sc_hd__decap_40_12
XFILLER_78_209 vssd1 vccd1 vssd1 vccd1 X2_sky130_ef_sc_hd__decap_40_12
XFILLER_59_27 vssd1 vccd1 vssd1 vccd1 X2_sky130_ef_sc_hd__decap_40_12
XFILLER_101_531 vccd1 vssd1 vccd1 vssd1 X2_sky130_fd_sc_hd__fill_1
XFILLER_59_445 vssd1 vccd1 vccd1 vssd1 X2_sky130_fd_sc_hd__fill_2
XFILLER_86_253 vssd1 vccd1 vssd1 vccd1 X2_sky130_ef_sc_hd__decap_40_12
XFILLER_75_15 vssd1 vccd1 vssd1 vccd1 X2_sky130_ef_sc_hd__decap_40_12
XFILLER_46_139 vccd1 vssd1 vccd1 vssd1 X2_sky130_fd_sc_hd__fill_1
XFILLER_61_109 vssd1 vccd1 vccd1 vssd1 X2_sky130_fd_sc_hd__fill_2
XFILLER_42_301 vssd1 vccd1 vccd1 vssd1 X2_sky130_fd_sc_hd__fill_4
XFILLER_15_559 vccd1 vssd1 vccd1 vssd1 X2_sky130_fd_sc_hd__fill_1
XFILLER_24_41 vssd1 vccd1 vssd1 vccd1 X2_sky130_ef_sc_hd__decap_40_12
XFILLER_30_529 vssd1 vccd1 vccd1 vssd1 X2_sky130_fd_sc_hd__fill_2
XFILLER_91_69 vssd1 vccd1 vssd1 vccd1 X2_sky130_ef_sc_hd__decap_40_12
X_301_ vssd1 vccd1 vccd1 vssd1 _573_/D hold63/X _301_/S _301_/A0 X2_sky130_fd_sc_hd__mux2_1
XFILLER_42_389 vssd1 vccd1 vccd1 vssd1 X2_sky130_fd_sc_hd__fill_2
XFILLER_42_367 vccd1 vssd1 vccd1 vssd1 X2_sky130_fd_sc_hd__fill_1
XFILLER_24_85 vssd1 vccd1 vssd1 vccd1 X2_sky130_ef_sc_hd__decap_40_12
XFILLER_10_253 vssd1 vccd1 vssd1 vccd1 X2_sky130_ef_sc_hd__decap_40_12
XTAP_TAPCELL_ROW_79_1091 vccd1 vssd1 X2_sky130_fd_sc_hd__tapvpwrvgnd_1
XFILLER_97_529 vssd1 vccd1 vssd1 vccd1 X2_sky130_ef_sc_hd__decap_40_12
XFILLER_49_93 vssd1 vccd1 vssd1 vccd1 X2_sky130_ef_sc_hd__decap_40_12
XFILLER_92_245 vssd1 vccd1 vccd1 vssd1 X2_sky130_fd_sc_hd__fill_4
XFILLER_65_81 vssd1 vccd1 vssd1 vccd1 X2_sky130_ef_sc_hd__decap_40_12
XFILLER_52_109 vssd1 vccd1 vssd1 vccd1 X2_sky130_ef_sc_hd__decap_40_12
XFILLER_45_161 vssd1 vccd1 vccd1 vssd1 X2_sky130_fd_sc_hd__fill_4
XFILLER_33_334 vssd1 vccd1 vccd1 vssd1 X2_sky130_fd_sc_hd__fill_2
XFILLER_60_153 vssd1 vccd1 vssd1 vccd1 X2_sky130_ef_sc_hd__decap_40_12
XFILLER_14_581 vssd1 vccd1 vccd1 vssd1 X2_sky130_fd_sc_hd__fill_4
XFILLER_21_529 vssd1 vccd1 vssd1 vccd1 X2_sky130_ef_sc_hd__decap_40_12
XFILLER_60_197 vssd1 vccd1 vssd1 vccd1 X2_sky130_ef_sc_hd__decap_40_12
XTAP_TAPCELL_ROW_31_557 vccd1 vssd1 X2_sky130_fd_sc_hd__tapvpwrvgnd_1
XPHY_EDGE_ROW_49_Right_49 vccd1 vssd1 vccd1 vssd1 X2_sky130_fd_sc_hd__decap_3
XFILLER_88_529 vssd1 vccd1 vccd1 vssd1 X2_sky130_fd_sc_hd__fill_2
Xhold19 _547_/D _532_/Q vccd1 vssd1 vssd1 vccd1 X2_sky130_fd_sc_hd__dlygate4sd3_1
XFILLER_68_264 vssd1 vccd1 vccd1 vssd1 X2_sky130_fd_sc_hd__fill_2
XFILLER_68_253 vssd1 vccd1 vccd1 vssd1 X2_sky130_fd_sc_hd__fill_8
XTAP_TAPCELL_ROW_3_249 vccd1 vssd1 X2_sky130_fd_sc_hd__tapvpwrvgnd_1
XFILLER_28_139 vccd1 vssd1 vccd1 vssd1 X2_sky130_fd_sc_hd__fill_1
XFILLER_83_223 vccd1 vssd1 vccd1 vssd1 X2_sky130_fd_sc_hd__fill_1
XTAP_TAPCELL_ROW_39_646 vccd1 vssd1 X2_sky130_fd_sc_hd__tapvpwrvgnd_1
XTAP_TAPCELL_ROW_67_955 vccd1 vssd1 X2_sky130_fd_sc_hd__tapvpwrvgnd_1
XPHY_EDGE_ROW_58_Right_58 vccd1 vssd1 vccd1 vssd1 X2_sky130_fd_sc_hd__decap_3
XFILLER_24_301 vssd1 vccd1 vccd1 vssd1 X2_sky130_fd_sc_hd__fill_4
XFILLER_71_429 vssd1 vccd1 vssd1 vccd1 X2_sky130_ef_sc_hd__decap_40_12
XFILLER_43_109 vssd1 vccd1 vccd1 vssd1 X2_sky130_fd_sc_hd__fill_2
XFILLER_24_345 vssd1 vccd1 vssd1 vccd1 X2_sky130_ef_sc_hd__decap_40_12
XFILLER_101_57 vssd1 vccd1 vssd1 vccd1 X2_sky130_ef_sc_hd__decap_40_12
XFILLER_12_529 vssd1 vccd1 vccd1 vssd1 X2_sky130_fd_sc_hd__fill_2
XFILLER_24_389 vssd1 vccd1 vssd1 vccd1 X2_sky130_ef_sc_hd__decap_40_12
XFILLER_61_39 vssd1 vccd1 vssd1 vccd1 X2_sky130_ef_sc_hd__decap_40_12
XPHY_EDGE_ROW_67_Right_67 vccd1 vssd1 vccd1 vssd1 X2_sky130_fd_sc_hd__decap_3
XFILLER_3_205 vssd1 vccd1 vssd1 vccd1 X2_sky130_ef_sc_hd__decap_40_12
XFILLER_3_249 vssd1 vccd1 vssd1 vccd1 X2_sky130_ef_sc_hd__decap_40_12
XFILLER_10_65 vssd1 vccd1 vssd1 vccd1 X2_sky130_ef_sc_hd__decap_40_12
XFILLER_79_529 vssd1 vccd1 vssd1 vccd1 X2_sky130_ef_sc_hd__decap_40_12
XFILLER_87_573 vssd1 vccd1 vssd1 vccd1 X2_sky130_ef_sc_hd__decap_40_12
XFILLER_101_350 vssd1 vccd1 vccd1 vssd1 X2_sky130_fd_sc_hd__fill_2
XFILLER_47_404 vssd1 vccd1 vccd1 vssd1 X2_sky130_fd_sc_hd__fill_2
XPHY_EDGE_ROW_98_Left_200 vccd1 vssd1 vccd1 vssd1 X2_sky130_fd_sc_hd__decap_3
XFILLER_101_372 vssd1 vccd1 vccd1 vssd1 X2_sky130_fd_sc_hd__fill_2
XPHY_EDGE_ROW_76_Right_76 vccd1 vssd1 vccd1 vssd1 X2_sky130_fd_sc_hd__decap_3
XFILLER_74_245 vssd1 vccd1 vccd1 vssd1 X2_sky130_fd_sc_hd__fill_4
XFILLER_27_161 vssd1 vccd1 vccd1 vssd1 X2_sky130_fd_sc_hd__fill_4
XFILLER_34_109 vssd1 vccd1 vssd1 vccd1 X2_sky130_ef_sc_hd__decap_40_12
XFILLER_74_289 vssd1 vccd1 vssd1 vccd1 X2_sky130_ef_sc_hd__decap_40_12
XFILLER_43_610 vssd1 vccd1 vccd1 vssd1 X2_sky130_fd_sc_hd__fill_2
XFILLER_42_153 vssd1 vccd1 vssd1 vccd1 X2_sky130_ef_sc_hd__decap_40_12
XFILLER_15_389 vssd1 vccd1 vccd1 vssd1 X2_sky130_fd_sc_hd__fill_2
XFILLER_30_326 vssd1 vccd1 vccd1 vssd1 X2_sky130_fd_sc_hd__fill_2
XFILLER_70_473 vssd1 vccd1 vccd1 vssd1 X2_sky130_fd_sc_hd__fill_2
XFILLER_42_197 vssd1 vccd1 vccd1 vssd1 X2_sky130_fd_sc_hd__fill_4
XFILLER_11_573 vssd1 vccd1 vssd1 vccd1 X2_sky130_ef_sc_hd__decap_40_12
XPHY_EDGE_ROW_85_Right_85 vccd1 vssd1 vccd1 vssd1 X2_sky130_fd_sc_hd__decap_3
XTAP_TAPCELL_ROW_90_1206 vccd1 vssd1 X2_sky130_fd_sc_hd__tapvpwrvgnd_1
XFILLER_97_337 vccd1 vssd1 vccd1 vssd1 X2_sky130_fd_sc_hd__fill_1
XPHY_EDGE_ROW_94_Right_94 vccd1 vssd1 vccd1 vssd1 X2_sky130_fd_sc_hd__decap_3
XFILLER_38_415 vssd1 vccd1 vccd1 vssd1 X2_sky130_fd_sc_hd__fill_2
XFILLER_65_223 vccd1 vssd1 vccd1 vssd1 X2_sky130_fd_sc_hd__fill_1
XTAP_TAPCELL_ROW_0_208 vccd1 vssd1 X2_sky130_fd_sc_hd__tapvpwrvgnd_1
XTAP_TAPCELL_ROW_0_219 vccd1 vssd1 X2_sky130_fd_sc_hd__tapvpwrvgnd_1
XFILLER_25_109 vssd1 vccd1 vccd1 vssd1 X2_sky130_fd_sc_hd__fill_2
XFILLER_34_610 vssd1 vccd1 vccd1 vssd1 X2_sky130_fd_sc_hd__fill_2
XTAP_TAPCELL_ROW_36_616 vccd1 vssd1 X2_sky130_fd_sc_hd__tapvpwrvgnd_1
XTAP_TAPCELL_ROW_64_925 vccd1 vssd1 X2_sky130_fd_sc_hd__tapvpwrvgnd_1
XFILLER_21_337 vssd1 vccd1 vssd1 vccd1 X2_sky130_ef_sc_hd__decap_40_12
XFILLER_61_473 vssd1 vccd1 vssd1 vccd1 X2_sky130_ef_sc_hd__decap_40_12
XTAP_TAPCELL_ROW_16_395 vccd1 vssd1 X2_sky130_fd_sc_hd__tapvpwrvgnd_1
XTAP_TAPCELL_ROW_8_308 vccd1 vssd1 X2_sky130_fd_sc_hd__tapvpwrvgnd_1
XFILLER_56_245 vssd1 vccd1 vccd1 vssd1 X2_sky130_fd_sc_hd__fill_4
XFILLER_16_109 vssd1 vccd1 vssd1 vccd1 X2_sky130_ef_sc_hd__decap_40_12
XFILLER_84_587 vccd1 vssd1 vccd1 vssd1 X2_sky130_fd_sc_hd__fill_1
XFILLER_44_418 vssd1 vccd1 vccd1 vssd1 X2_sky130_fd_sc_hd__fill_2
XFILLER_71_237 vssd1 vccd1 vssd1 vccd1 X2_sky130_ef_sc_hd__decap_40_12
XFILLER_24_153 vssd1 vccd1 vssd1 vccd1 X2_sky130_ef_sc_hd__decap_40_12
XFILLER_72_27 vccd1 vssd1 vccd1 vssd1 X2_sky130_fd_sc_hd__fill_1
XFILLER_40_624 vccd1 vssd1 vccd1 vssd1 X2_sky130_fd_sc_hd__fill_1
XFILLER_24_197 vssd1 vccd1 vssd1 vccd1 X2_sky130_ef_sc_hd__decap_40_12
XFILLER_4_525 vssd1 vccd1 vccd1 vssd1 X2_sky130_fd_sc_hd__fill_4
XFILLER_4_569 vssd1 vccd1 vssd1 vccd1 X2_sky130_ef_sc_hd__decap_40_12
XTAP_TAPCELL_ROW_76_1061 vccd1 vssd1 X2_sky130_fd_sc_hd__tapvpwrvgnd_1
XFILLER_97_57 vssd1 vccd1 vssd1 vccd1 X2_sky130_ef_sc_hd__decap_40_12
XFILLER_79_337 vssd1 vccd1 vssd1 vccd1 X2_sky130_ef_sc_hd__decap_40_12
XANTENNA_input35_A wbs_dat_i[6] vssd1 vccd1 vccd1 vssd1 X2_sky130_fd_sc_hd__diode_2
XFILLER_87_370 vssd1 vccd1 vssd1 vccd1 X2_sky130_ef_sc_hd__decap_40_12
XFILLER_47_223 vccd1 vssd1 vccd1 vssd1 X2_sky130_fd_sc_hd__fill_1
XFILLER_35_429 vssd1 vccd1 vccd1 vssd1 X2_sky130_fd_sc_hd__fill_8
XFILLER_90_513 vssd1 vccd1 vssd1 vccd1 X2_sky130_ef_sc_hd__decap_40_12
XFILLER_90_557 vssd1 vccd1 vssd1 vccd1 X2_sky130_ef_sc_hd__decap_40_12
XFILLER_62_237 vssd1 vccd1 vssd1 vccd1 X2_sky130_ef_sc_hd__decap_40_12
XFILLER_46_83 vccd1 vssd1 vccd1 vssd1 X2_sky130_fd_sc_hd__fill_1
XFILLER_31_624 vccd1 vssd1 vccd1 vssd1 X2_sky130_fd_sc_hd__fill_1
XFILLER_43_495 vccd1 vssd1 vccd1 vssd1 X2_sky130_fd_sc_hd__fill_1
XTAP_TAPCELL_ROW_13_365 vccd1 vssd1 X2_sky130_fd_sc_hd__tapvpwrvgnd_1
XTAP_TAPCELL_ROW_41_674 vccd1 vssd1 X2_sky130_fd_sc_hd__tapvpwrvgnd_1
XFILLER_7_55 vccd1 vssd1 vccd1 vssd1 X2_sky130_fd_sc_hd__fill_1
XFILLER_30_189 vssd1 vccd1 vccd1 vssd1 X2_sky130_fd_sc_hd__fill_4
XFILLER_7_385 vssd1 vccd1 vccd1 vssd1 X2_sky130_fd_sc_hd__fill_4
XFILLER_98_613 vssd1 vccd1 vssd1 vccd1 X2_sky130_ef_sc_hd__decap_40_12
XFILLER_30_3 vssd1 vccd1 vssd1 vccd1 X2_sky130_ef_sc_hd__decap_40_12
XFILLER_97_167 vccd1 vssd1 vccd1 vssd1 X2_sky130_fd_sc_hd__fill_1
XFILLER_38_245 vssd1 vccd1 vccd1 vssd1 X2_sky130_fd_sc_hd__fill_4
XFILLER_93_340 vssd1 vccd1 vssd1 vccd1 X2_sky130_ef_sc_hd__decap_40_12
XFILLER_66_587 vccd1 vssd1 vccd1 vssd1 X2_sky130_fd_sc_hd__fill_1
XTAP_TAPCELL_ROW_49_763 vccd1 vssd1 X2_sky130_fd_sc_hd__tapvpwrvgnd_1
XFILLER_81_557 vssd1 vccd1 vccd1 vssd1 X2_sky130_fd_sc_hd__fill_2
XFILLER_53_237 vssd1 vccd1 vssd1 vccd1 X2_sky130_ef_sc_hd__decap_40_12
XFILLER_34_440 vssd1 vccd1 vccd1 vssd1 X2_sky130_fd_sc_hd__fill_2
XFILLER_53_259 vccd1 vssd1 vccd1 vssd1 X2_sky130_fd_sc_hd__fill_1
XFILLER_22_613 vssd1 vccd1 vccd1 vssd1 X2_sky130_fd_sc_hd__fill_8
XFILLER_22_624 vccd1 vssd1 vccd1 vssd1 X2_sky130_fd_sc_hd__fill_1
XFILLER_61_281 vssd1 vccd1 vssd1 vccd1 X2_sky130_ef_sc_hd__decap_40_12
XFILLER_21_167 vccd1 vssd1 vccd1 vssd1 X2_sky130_fd_sc_hd__fill_1
XANTENNA__337__A2 _317_/B vssd1 vccd1 vccd1 vssd1 X2_sky130_fd_sc_hd__diode_2
XFILLER_1_517 vssd1 vccd1 vssd1 vccd1 X2_sky130_ef_sc_hd__decap_40_12
XFILLER_89_613 vssd1 vccd1 vccd1 vssd1 X2_sky130_fd_sc_hd__fill_2
XFILLER_88_189 vssd1 vccd1 vccd1 vssd1 X2_sky130_fd_sc_hd__fill_4
XFILLER_29_223 vccd1 vssd1 vccd1 vssd1 X2_sky130_fd_sc_hd__fill_1
XFILLER_83_15 vssd1 vccd1 vssd1 vccd1 X2_sky130_ef_sc_hd__decap_40_12
XFILLER_72_513 vssd1 vccd1 vssd1 vccd1 X2_sky130_ef_sc_hd__decap_40_12
XFILLER_17_429 vssd1 vccd1 vssd1 vccd1 X2_sky130_ef_sc_hd__decap_40_12
XFILLER_29_289 vssd1 vccd1 vccd1 vssd1 X2_sky130_fd_sc_hd__fill_2
XFILLER_57_598 vssd1 vccd1 vccd1 vssd1 X2_sky130_fd_sc_hd__fill_4
XFILLER_44_226 vssd1 vccd1 vssd1 vccd1 X2_sky130_ef_sc_hd__decap_40_12
XFILLER_16_53 vssd1 vccd1 vssd1 vccd1 X2_sky130_ef_sc_hd__decap_40_12
X_480_ vccd1 vssd1 vccd1 vssd1 _480_/Y _529_/A X2_sky130_fd_sc_hd__inv_2
XFILLER_72_557 vssd1 vccd1 vssd1 vccd1 X2_sky130_ef_sc_hd__decap_40_12
XFILLER_13_613 vssd1 vccd1 vccd1 vssd1 X2_sky130_fd_sc_hd__fill_2
XPHY_EDGE_ROW_17_Left_119 vccd1 vssd1 vccd1 vssd1 X2_sky130_fd_sc_hd__decap_3
XFILLER_25_473 vssd1 vccd1 vssd1 vccd1 X2_sky130_ef_sc_hd__decap_40_12
XFILLER_40_410 vssd1 vccd1 vccd1 vssd1 X2_sky130_fd_sc_hd__fill_8
XFILLER_9_617 vssd1 vccd1 vccd1 vssd1 X2_sky130_fd_sc_hd__fill_8
XFILLER_16_97 vssd1 vccd1 vssd1 vccd1 X2_sky130_ef_sc_hd__decap_40_12
XFILLER_40_421 vssd1 vccd1 vssd1 vccd1 X2_sky130_ef_sc_hd__decap_40_12
XANTENNA__328__A2 _317_/B vssd1 vccd1 vccd1 vssd1 X2_sky130_fd_sc_hd__diode_2
XFILLER_12_189 vssd1 vccd1 vccd1 vssd1 X2_sky130_fd_sc_hd__fill_4
XFILLER_32_41 vssd1 vccd1 vssd1 vccd1 X2_sky130_ef_sc_hd__decap_40_12
XTAP_TAPCELL_ROW_10_335 vccd1 vssd1 X2_sky130_fd_sc_hd__tapvpwrvgnd_1
XFILLER_32_85 vssd1 vccd1 vssd1 vccd1 X2_sky130_ef_sc_hd__decap_40_12
XFILLER_4_333 vssd1 vccd1 vssd1 vccd1 X2_sky130_ef_sc_hd__decap_40_12
XPHY_EDGE_ROW_26_Left_128 vccd1 vssd1 vccd1 vssd1 X2_sky130_fd_sc_hd__decap_3
XFILLER_4_377 vssd1 vccd1 vssd1 vccd1 X2_sky130_ef_sc_hd__decap_40_12
XFILLER_0_561 vssd1 vccd1 vssd1 vccd1 X2_sky130_ef_sc_hd__decap_40_12
XFILLER_79_167 vccd1 vssd1 vccd1 vssd1 X2_sky130_fd_sc_hd__fill_1
XFILLER_94_137 vssd1 vccd1 vccd1 vssd1 X2_sky130_fd_sc_hd__fill_2
XFILLER_75_373 vssd1 vccd1 vssd1 vccd1 X2_sky130_ef_sc_hd__decap_40_12
XFILLER_57_93 vssd1 vccd1 vssd1 vccd1 X2_sky130_ef_sc_hd__decap_40_12
XFILLER_48_587 vccd1 vssd1 vccd1 vssd1 X2_sky130_fd_sc_hd__fill_1
XFILLER_48_565 vssd1 vccd1 vccd1 vssd1 X2_sky130_fd_sc_hd__fill_2
XTAP_TAPCELL_ROW_18_413 vccd1 vssd1 X2_sky130_fd_sc_hd__tapvpwrvgnd_1
XFILLER_35_237 vssd1 vccd1 vssd1 vccd1 X2_sky130_ef_sc_hd__decap_40_12
XTAP_TAPCELL_ROW_46_722 vccd1 vssd1 X2_sky130_fd_sc_hd__tapvpwrvgnd_1
XANTENNA_clkload0_A _553_/CLK vssd1 vccd1 vccd1 vssd1 X2_sky130_fd_sc_hd__diode_2
XPHY_EDGE_ROW_35_Left_137 vccd1 vssd1 vccd1 vssd1 X2_sky130_fd_sc_hd__decap_3
XFILLER_90_365 vssd1 vccd1 vssd1 vccd1 X2_sky130_ef_sc_hd__decap_40_12
XFILLER_63_557 vssd1 vccd1 vccd1 vssd1 X2_sky130_fd_sc_hd__fill_2
XFILLER_16_473 vssd1 vccd1 vccd1 vssd1 X2_sky130_fd_sc_hd__fill_2
XFILLER_73_81 vssd1 vccd1 vssd1 vccd1 X2_sky130_ef_sc_hd__decap_40_12
XFILLER_50_218 vssd1 vccd1 vssd1 vccd1 X2_sky130_ef_sc_hd__decap_40_12
XFILLER_43_281 vssd1 vccd1 vssd1 vccd1 X2_sky130_ef_sc_hd__decap_40_12
XANTENNA__319__A2 _291_/B vssd1 vccd1 vccd1 vssd1 X2_sky130_fd_sc_hd__diode_2
XFILLER_78_3 vssd1 vccd1 vssd1 vccd1 X2_sky130_ef_sc_hd__decap_40_12
XANTENNA__281__S _289_/S vssd1 vccd1 vccd1 vssd1 X2_sky130_fd_sc_hd__diode_2
XFILLER_7_193 vssd1 vccd1 vssd1 vccd1 X2_sky130_ef_sc_hd__decap_40_12
XPHY_EDGE_ROW_44_Left_146 vccd1 vssd1 vccd1 vssd1 X2_sky130_fd_sc_hd__decap_3
XTAP_TAPCELL_ROW_96_1278 vccd1 vssd1 X2_sky130_fd_sc_hd__tapvpwrvgnd_1
XANTENNA_hold43_A _537_/Q vssd1 vccd1 vccd1 vssd1 X2_sky130_fd_sc_hd__diode_2
XFILLER_98_421 vccd1 vssd1 vccd1 vssd1 X2_sky130_fd_sc_hd__fill_1
XFILLER_98_443 vssd1 vccd1 vccd1 vssd1 X2_sky130_fd_sc_hd__fill_2
XFILLER_85_137 vssd1 vccd1 vssd1 vccd1 X2_sky130_ef_sc_hd__decap_40_12
XFILLER_93_181 vssd1 vccd1 vssd1 vccd1 X2_sky130_ef_sc_hd__decap_40_12
XPHY_EDGE_ROW_53_Left_155 vccd1 vssd1 vccd1 vssd1 X2_sky130_fd_sc_hd__decap_3
XFILLER_41_218 vssd1 vccd1 vccd1 vssd1 X2_sky130_fd_sc_hd__fill_2
XFILLER_22_421 vssd1 vccd1 vssd1 vccd1 X2_sky130_ef_sc_hd__decap_40_12
XPHY_EDGE_ROW_62_Left_164 vccd1 vssd1 vccd1 vssd1 X2_sky130_fd_sc_hd__decap_3
XFILLER_78_15 vssd1 vccd1 vssd1 vccd1 X2_sky130_ef_sc_hd__decap_40_12
XFILLER_1_325 vssd1 vccd1 vccd1 vssd1 X2_sky130_fd_sc_hd__fill_8
XTAP_TAPCELL_ROW_73_1020 vccd1 vssd1 X2_sky130_fd_sc_hd__tapvpwrvgnd_1
XFILLER_1_358 vssd1 vccd1 vssd1 vccd1 X2_sky130_ef_sc_hd__decap_40_12
XFILLER_49_329 vssd1 vccd1 vccd1 vssd1 X2_sky130_fd_sc_hd__fill_4
XFILLER_76_137 vssd1 vccd1 vccd1 vssd1 X2_sky130_fd_sc_hd__fill_2
X_601_ vssd1 vccd1 vccd1 vssd1 _601_/CLK _601_/D _521_/Y _601_/Q X2_sky130_fd_sc_hd__dfrtp_1
XPHY_EDGE_ROW_71_Left_173 vccd1 vssd1 vccd1 vssd1 X2_sky130_fd_sc_hd__decap_3
XFILLER_17_237 vssd1 vccd1 vssd1 vccd1 X2_sky130_ef_sc_hd__decap_40_12
XFILLER_72_321 vssd1 vccd1 vssd1 vccd1 X2_sky130_ef_sc_hd__decap_40_12
X_532_ vssd1 vccd1 vccd1 vssd1 _553_/CLK _532_/D _452_/Y _532_/Q X2_sky130_fd_sc_hd__dfrtp_4
XFILLER_72_365 vssd1 vccd1 vssd1 vccd1 X2_sky130_ef_sc_hd__decap_40_12
X_463_ vccd1 vssd1 vccd1 vssd1 _463_/Y _529_/A X2_sky130_fd_sc_hd__inv_2
XFILLER_25_281 vssd1 vccd1 vssd1 vccd1 X2_sky130_ef_sc_hd__decap_40_12
X_394_ vccd1 vssd1 vssd1 vccd1 _414_/B _394_/Y _394_/B X2_sky130_fd_sc_hd__nand2_1
XFILLER_43_51 vssd1 vccd1 vccd1 vssd1 X2_sky130_fd_sc_hd__fill_4
XFILLER_9_447 vccd1 vssd1 vccd1 vssd1 X2_sky130_fd_sc_hd__fill_1
XTAP_TAPCELL_ROW_23_471 vccd1 vssd1 X2_sky130_fd_sc_hd__tapvpwrvgnd_1
XPHY_EDGE_ROW_80_Left_182 vccd1 vssd1 vccd1 vssd1 X2_sky130_fd_sc_hd__decap_3
XTAP_TAPCELL_ROW_51_780 vccd1 vssd1 X2_sky130_fd_sc_hd__tapvpwrvgnd_1
XFILLER_4_141 vssd1 vccd1 vssd1 vccd1 X2_sky130_ef_sc_hd__decap_40_12
XFILLER_68_81 vssd1 vccd1 vccd1 vssd1 X2_sky130_fd_sc_hd__fill_2
XFILLER_0_391 vccd1 vssd1 vccd1 vssd1 X2_sky130_fd_sc_hd__fill_1
XFILLER_67_137 vssd1 vccd1 vssd1 vccd1 X2_sky130_ef_sc_hd__decap_40_12
XFILLER_36_524 vssd1 vccd1 vccd1 vssd1 X2_sky130_fd_sc_hd__fill_8
XFILLER_75_181 vssd1 vccd1 vssd1 vccd1 X2_sky130_ef_sc_hd__decap_40_12
XFILLER_51_505 vssd1 vccd1 vssd1 vccd1 X2_sky130_ef_sc_hd__decap_40_12
XANTENNA__276__S _289_/S vssd1 vccd1 vccd1 vssd1 X2_sky130_fd_sc_hd__diode_2
XFILLER_90_195 vccd1 vssd1 vccd1 vssd1 X2_sky130_fd_sc_hd__fill_1
XFILLER_31_273 vssd1 vccd1 vccd1 vssd1 X2_sky130_fd_sc_hd__fill_4
XFILLER_98_251 vccd1 vssd1 vccd1 vssd1 X2_sky130_fd_sc_hd__fill_1
XFILLER_86_413 vssd1 vccd1 vccd1 vssd1 X2_sky130_fd_sc_hd__fill_4
XFILLER_48_29 vssd1 vccd1 vssd1 vccd1 X2_sky130_ef_sc_hd__decap_40_12
XFILLER_98_295 vccd1 vssd1 vccd1 vssd1 X2_sky130_fd_sc_hd__fill_1
XFILLER_86_457 vssd1 vccd1 vssd1 vccd1 X2_sky130_ef_sc_hd__decap_40_12
XFILLER_58_137 vssd1 vccd1 vccd1 vssd1 X2_sky130_fd_sc_hd__fill_2
XFILLER_39_362 vssd1 vccd1 vssd1 vccd1 X2_sky130_ef_sc_hd__decap_40_12
XFILLER_100_245 vssd1 vccd1 vccd1 vssd1 X2_sky130_fd_sc_hd__fill_4
XFILLER_74_619 vssd1 vccd1 vccd1 vssd1 X2_sky130_fd_sc_hd__fill_2
XFILLER_100_289 vssd1 vccd1 vccd1 vssd1 X2_sky130_fd_sc_hd__fill_4
XFILLER_54_321 vssd1 vccd1 vccd1 vssd1 X2_sky130_fd_sc_hd__fill_4
XFILLER_27_557 vssd1 vccd1 vccd1 vssd1 X2_sky130_fd_sc_hd__fill_2
XFILLER_54_332 vssd1 vccd1 vccd1 vssd1 X2_sky130_fd_sc_hd__fill_8
XFILLER_54_365 vssd1 vccd1 vssd1 vccd1 X2_sky130_ef_sc_hd__decap_40_12
XFILLER_42_516 vssd1 vccd1 vccd1 vssd1 X2_sky130_fd_sc_hd__fill_2
XFILLER_22_251 vccd1 vssd1 vccd1 vssd1 X2_sky130_fd_sc_hd__fill_1
XFILLER_80_27 vccd1 vssd1 vccd1 vssd1 X2_sky130_fd_sc_hd__fill_1
XFILLER_10_413 vssd1 vccd1 vccd1 vssd1 X2_sky130_fd_sc_hd__fill_4
XFILLER_6_417 vssd1 vccd1 vccd1 vssd1 X2_sky130_fd_sc_hd__fill_2
XFILLER_10_457 vssd1 vccd1 vssd1 vccd1 X2_sky130_ef_sc_hd__decap_40_12
XTAP_TAPCELL_ROW_20_441 vccd1 vssd1 X2_sky130_fd_sc_hd__tapvpwrvgnd_1
XFILLER_2_601 vssd1 vccd1 vssd1 vccd1 X2_sky130_ef_sc_hd__decap_40_12
XFILLER_89_69 vssd1 vccd1 vssd1 vccd1 X2_sky130_ef_sc_hd__decap_40_12
XFILLER_1_111 vccd1 vssd1 vccd1 vssd1 X2_sky130_fd_sc_hd__fill_1
XFILLER_8_3 vssd1 vccd1 vssd1 vccd1 X2_sky130_ef_sc_hd__decap_40_12
XFILLER_89_273 vssd1 vccd1 vccd1 vssd1 X2_sky130_fd_sc_hd__fill_4
XFILLER_49_137 vssd1 vccd1 vssd1 vccd1 X2_sky130_ef_sc_hd__decap_40_12
XFILLER_65_619 vccd1 vssd1 vccd1 vssd1 X2_sky130_fd_sc_hd__fill_1
XFILLER_65_608 vssd1 vccd1 vccd1 vssd1 X2_sky130_fd_sc_hd__fill_8
XFILLER_18_513 vssd1 vccd1 vssd1 vccd1 X2_sky130_ef_sc_hd__decap_40_12
XFILLER_18_557 vssd1 vccd1 vssd1 vccd1 X2_sky130_ef_sc_hd__decap_40_12
XTAP_TAPCELL_ROW_28_530 vccd1 vssd1 X2_sky130_fd_sc_hd__tapvpwrvgnd_1
XFILLER_57_181 vssd1 vccd1 vssd1 vccd1 X2_sky130_ef_sc_hd__decap_40_12
XFILLER_33_505 vccd1 vssd1 vccd1 vssd1 X2_sky130_fd_sc_hd__fill_1
X_515_ vccd1 vssd1 vccd1 vssd1 _515_/Y _517_/A X2_sky130_fd_sc_hd__inv_2
XTAP_TAPCELL_ROW_82_1119 vccd1 vssd1 X2_sky130_fd_sc_hd__tapvpwrvgnd_1
XFILLER_72_195 vccd1 vssd1 vccd1 vssd1 X2_sky130_fd_sc_hd__fill_1
XFILLER_60_324 vssd1 vccd1 vssd1 vccd1 X2_sky130_ef_sc_hd__decap_40_12
XFILLER_54_83 vccd1 vssd1 vccd1 vssd1 X2_sky130_fd_sc_hd__fill_1
X_446_ vccd1 vssd1 vccd1 vssd1 hold45/X _585_/D _446_/A1 _440_/Y X2_sky130_fd_sc_hd__a21boi_1
XFILLER_13_273 vssd1 vccd1 vccd1 vssd1 X2_sky130_fd_sc_hd__fill_4
X_377_ vccd1 vssd1 vssd1 vccd1 _379_/C _377_/B _377_/Y X2_sky130_fd_sc_hd__nor2_1
XFILLER_9_277 vssd1 vccd1 vccd1 vssd1 X2_sky130_fd_sc_hd__fill_2
XFILLER_5_461 vssd1 vccd1 vssd1 vccd1 X2_sky130_ef_sc_hd__decap_40_12
XTAP_TAPCELL_ROW_93_1248 vccd1 vssd1 X2_sky130_fd_sc_hd__tapvpwrvgnd_1
XFILLER_68_413 vssd1 vccd1 vccd1 vssd1 X2_sky130_fd_sc_hd__fill_4
XFILLER_95_221 vssd1 vccd1 vccd1 vssd1 X2_sky130_fd_sc_hd__fill_2
XFILLER_83_405 vssd1 vccd1 vssd1 vccd1 X2_sky130_ef_sc_hd__decap_40_12
XFILLER_68_457 vssd1 vccd1 vssd1 vccd1 X2_sky130_ef_sc_hd__decap_40_12
XFILLER_56_608 vssd1 vccd1 vccd1 vssd1 X2_sky130_fd_sc_hd__fill_8
XFILLER_95_298 vssd1 vccd1 vccd1 vssd1 X2_sky130_fd_sc_hd__fill_2
XFILLER_83_449 vssd1 vccd1 vssd1 vccd1 X2_sky130_ef_sc_hd__decap_40_12
XFILLER_36_321 vssd1 vccd1 vssd1 vccd1 X2_sky130_ef_sc_hd__decap_40_12
XTAP_TAPCELL_ROW_54_809 vccd1 vssd1 X2_sky130_fd_sc_hd__tapvpwrvgnd_1
XFILLER_36_365 vssd1 vccd1 vssd1 vccd1 X2_sky130_ef_sc_hd__decap_40_12
XFILLER_51_313 vssd1 vccd1 vccd1 vssd1 X2_sky130_fd_sc_hd__fill_2
XFILLER_51_335 vccd1 vssd1 vccd1 vssd1 X2_sky130_fd_sc_hd__fill_1
XTAP_TAPCELL_ROW_34_599 vccd1 vssd1 X2_sky130_fd_sc_hd__tapvpwrvgnd_1
XTAP_TAPCELL_ROW_62_897 vccd1 vssd1 X2_sky130_fd_sc_hd__tapvpwrvgnd_1
XANTENNA__449__A1 _449_/A1 vssd1 vccd1 vccd1 vssd1 X2_sky130_fd_sc_hd__diode_2
XFILLER_59_39 vssd1 vccd1 vssd1 vccd1 X2_sky130_ef_sc_hd__decap_40_12
XFILLER_86_221 vssd1 vccd1 vssd1 vccd1 X2_sky130_ef_sc_hd__decap_40_12
XFILLER_86_265 vssd1 vccd1 vssd1 vccd1 X2_sky130_ef_sc_hd__decap_40_12
XFILLER_75_27 vssd1 vccd1 vssd1 vccd1 X2_sky130_ef_sc_hd__decap_40_12
XFILLER_101_587 vccd1 vssd1 vccd1 vssd1 X2_sky130_fd_sc_hd__fill_1
XFILLER_39_181 vssd1 vccd1 vssd1 vccd1 X2_sky130_ef_sc_hd__decap_40_12
XFILLER_15_505 vssd1 vccd1 vssd1 vccd1 X2_sky130_ef_sc_hd__decap_40_12
XTAP_TAPCELL_ROW_25_500 vccd1 vssd1 X2_sky130_fd_sc_hd__tapvpwrvgnd_1
XFILLER_91_15 vssd1 vccd1 vssd1 vccd1 X2_sky130_ef_sc_hd__decap_40_12
XFILLER_54_195 vccd1 vssd1 vccd1 vssd1 X2_sky130_fd_sc_hd__fill_1
X_300_ vccd1 vssd1 vccd1 vssd1 _320_/B _310_/B _301_/S _341_/C _291_/A X2_sky130_fd_sc_hd__or4bb_1
XFILLER_42_313 vssd1 vccd1 vccd1 vssd1 X2_sky130_fd_sc_hd__fill_2
XFILLER_24_53 vssd1 vccd1 vssd1 vccd1 X2_sky130_ef_sc_hd__decap_40_12
XFILLER_10_221 vssd1 vccd1 vssd1 vccd1 X2_sky130_ef_sc_hd__decap_40_12
XFILLER_24_97 vssd1 vccd1 vssd1 vccd1 X2_sky130_ef_sc_hd__decap_40_12
XFILLER_10_265 vssd1 vccd1 vssd1 vccd1 X2_sky130_ef_sc_hd__decap_40_12
XFILLER_40_41 vssd1 vccd1 vssd1 vccd1 X2_sky130_ef_sc_hd__decap_40_12
XFILLER_40_85 vssd1 vccd1 vssd1 vccd1 X2_sky130_ef_sc_hd__decap_40_12
XTAP_TAPCELL_ROW_79_1092 vccd1 vssd1 X2_sky130_fd_sc_hd__tapvpwrvgnd_1
XFILLER_2_475 vccd1 vssd1 vccd1 vssd1 X2_sky130_fd_sc_hd__fill_1
XFILLER_77_221 vssd1 vccd1 vccd1 vssd1 X2_sky130_fd_sc_hd__fill_2
XFILLER_65_405 vssd1 vccd1 vssd1 vccd1 X2_sky130_ef_sc_hd__decap_40_12
XTAP_TAPCELL_ROW_5_280 vccd1 vssd1 X2_sky130_fd_sc_hd__tapvpwrvgnd_1
XFILLER_1_57 vssd1 vccd1 vssd1 vccd1 X2_sky130_ef_sc_hd__decap_40_12
XFILLER_18_321 vssd1 vccd1 vssd1 vccd1 X2_sky130_ef_sc_hd__decap_40_12
XFILLER_65_449 vssd1 vccd1 vssd1 vccd1 X2_sky130_ef_sc_hd__decap_40_12
XFILLER_18_365 vssd1 vccd1 vssd1 vccd1 X2_sky130_ef_sc_hd__decap_40_12
XFILLER_80_419 vccd1 vssd1 vccd1 vssd1 X2_sky130_fd_sc_hd__fill_1
XFILLER_65_93 vssd1 vccd1 vssd1 vccd1 X2_sky130_ef_sc_hd__decap_40_12
XFILLER_61_600 vssd1 vccd1 vccd1 vssd1 X2_sky130_fd_sc_hd__fill_4
XFILLER_60_121 vssd1 vccd1 vssd1 vccd1 X2_sky130_ef_sc_hd__decap_40_12
XFILLER_60_165 vssd1 vccd1 vssd1 vccd1 X2_sky130_ef_sc_hd__decap_40_12
XFILLER_81_81 vssd1 vccd1 vssd1 vccd1 X2_sky130_ef_sc_hd__decap_40_12
X_429_ vccd1 vssd1 _430_/C _428_/X _553_/D _552_/D _554_/D vssd1 vccd1 X2_sky130_fd_sc_hd__a31o_1
XTAP_TAPCELL_ROW_31_558 vccd1 vssd1 X2_sky130_fd_sc_hd__tapvpwrvgnd_1
XFILLER_60_3 vssd1 vccd1 vssd1 vccd1 X2_sky130_ef_sc_hd__decap_40_12
XFILLER_68_221 vssd1 vccd1 vssd1 vccd1 X2_sky130_ef_sc_hd__decap_40_12
Xinput1 vssd1 vccd1 _530_/D adc_data_in[0] vccd1 vssd1 X2_sky130_fd_sc_hd__buf_1
XFILLER_96_585 vssd1 vccd1 vccd1 vssd1 X2_sky130_fd_sc_hd__fill_2
XTAP_TAPCELL_ROW_39_647 vccd1 vssd1 X2_sky130_fd_sc_hd__tapvpwrvgnd_1
XTAP_TAPCELL_ROW_67_956 vccd1 vssd1 X2_sky130_fd_sc_hd__tapvpwrvgnd_1
XFILLER_36_195 vccd1 vssd1 vccd1 vssd1 X2_sky130_fd_sc_hd__fill_1
XFILLER_24_357 vssd1 vccd1 vccd1 vssd1 X2_sky130_fd_sc_hd__fill_4
XFILLER_101_69 vssd1 vccd1 vssd1 vccd1 X2_sky130_ef_sc_hd__decap_40_12
XFILLER_51_165 vssd1 vccd1 vccd1 vssd1 X2_sky130_fd_sc_hd__fill_2
XFILLER_20_585 vssd1 vccd1 vccd1 vssd1 X2_sky130_fd_sc_hd__fill_2
XFILLER_3_217 vssd1 vccd1 vccd1 vssd1 X2_sky130_fd_sc_hd__fill_4
XFILLER_10_77 vssd1 vccd1 vccd1 vssd1 X2_sky130_fd_sc_hd__fill_4
XFILLER_99_390 vssd1 vccd1 vccd1 vssd1 X2_sky130_fd_sc_hd__fill_2
XFILLER_86_15 vssd1 vccd1 vssd1 vccd1 X2_sky130_ef_sc_hd__decap_40_12
XFILLER_59_221 vssd1 vccd1 vccd1 vssd1 X2_sky130_fd_sc_hd__fill_2
XFILLER_87_541 vssd1 vccd1 vssd1 vccd1 X2_sky130_ef_sc_hd__decap_40_12
XFILLER_87_585 vssd1 vccd1 vssd1 vccd1 X2_sky130_ef_sc_hd__decap_40_12
XFILLER_59_265 vccd1 vssd1 vccd1 vssd1 X2_sky130_fd_sc_hd__fill_1
XFILLER_47_416 vssd1 vccd1 vssd1 vccd1 X2_sky130_ef_sc_hd__decap_40_12
XFILLER_47_449 vssd1 vccd1 vccd1 vssd1 X2_sky130_fd_sc_hd__fill_8
XFILLER_62_419 vccd1 vssd1 vccd1 vssd1 X2_sky130_fd_sc_hd__fill_1
XFILLER_15_335 vccd1 vssd1 vccd1 vssd1 X2_sky130_fd_sc_hd__fill_1
XFILLER_42_121 vssd1 vccd1 vssd1 vccd1 X2_sky130_ef_sc_hd__decap_40_12
XFILLER_42_165 vssd1 vccd1 vssd1 vccd1 X2_sky130_ef_sc_hd__decap_40_12
XFILLER_11_541 vssd1 vccd1 vssd1 vccd1 X2_sky130_ef_sc_hd__decap_40_12
XFILLER_7_501 vssd1 vccd1 vccd1 vssd1 X2_sky130_fd_sc_hd__fill_2
XFILLER_11_585 vssd1 vccd1 vssd1 vccd1 X2_sky130_ef_sc_hd__decap_40_12
XFILLER_51_51 vssd1 vccd1 vccd1 vssd1 X2_sky130_fd_sc_hd__fill_4
XTAP_TAPCELL_ROW_90_1207 vccd1 vssd1 X2_sky130_fd_sc_hd__tapvpwrvgnd_1
XFILLER_97_305 vssd1 vccd1 vssd1 vccd1 X2_sky130_ef_sc_hd__decap_40_12
XFILLER_38_405 vssd1 vccd1 vccd1 vssd1 X2_sky130_fd_sc_hd__fill_2
XFILLER_78_585 vssd1 vccd1 vccd1 vssd1 X2_sky130_fd_sc_hd__fill_2
XTAP_TAPCELL_ROW_0_209 vccd1 vssd1 X2_sky130_fd_sc_hd__tapvpwrvgnd_1
XFILLER_76_81 vssd1 vccd1 vccd1 vssd1 X2_sky130_fd_sc_hd__fill_2
XFILLER_65_257 vssd1 vccd1 vccd1 vssd1 X2_sky130_fd_sc_hd__fill_2
XTAP_TAPCELL_ROW_36_617 vccd1 vssd1 X2_sky130_fd_sc_hd__tapvpwrvgnd_1
XFILLER_65_279 vccd1 vssd1 vccd1 vssd1 X2_sky130_fd_sc_hd__fill_1
XTAP_TAPCELL_ROW_64_926 vccd1 vssd1 X2_sky130_fd_sc_hd__tapvpwrvgnd_1
XFILLER_18_195 vccd1 vssd1 vccd1 vssd1 X2_sky130_fd_sc_hd__fill_1
XFILLER_80_249 vssd1 vccd1 vccd1 vssd1 X2_sky130_fd_sc_hd__fill_2
XFILLER_61_441 vssd1 vccd1 vccd1 vssd1 X2_sky130_fd_sc_hd__fill_4
XFILLER_21_305 vssd1 vccd1 vssd1 vccd1 X2_sky130_ef_sc_hd__decap_40_12
XANTENNA__284__S _289_/S vssd1 vccd1 vccd1 vssd1 X2_sky130_fd_sc_hd__diode_2
XFILLER_33_165 vssd1 vccd1 vccd1 vssd1 X2_sky130_fd_sc_hd__fill_2
XFILLER_61_485 vssd1 vccd1 vssd1 vccd1 X2_sky130_ef_sc_hd__decap_40_12
XTAP_TAPCELL_ROW_16_396 vccd1 vssd1 X2_sky130_fd_sc_hd__tapvpwrvgnd_1
XFILLER_21_349 vssd1 vccd1 vssd1 vccd1 X2_sky130_ef_sc_hd__decap_40_12
XTAP_TAPCELL_ROW_8_309 vccd1 vssd1 X2_sky130_fd_sc_hd__tapvpwrvgnd_1
XFILLER_88_305 vssd1 vccd1 vccd1 vssd1 X2_sky130_fd_sc_hd__fill_2
XFILLER_88_349 vssd1 vccd1 vccd1 vssd1 X2_sky130_fd_sc_hd__fill_2
XFILLER_69_541 vssd1 vccd1 vssd1 vccd1 X2_sky130_ef_sc_hd__decap_40_12
XFILLER_29_405 vssd1 vccd1 vssd1 vccd1 X2_sky130_ef_sc_hd__decap_40_12
XFILLER_56_29 vssd1 vccd1 vssd1 vccd1 X2_sky130_ef_sc_hd__decap_40_12
XFILLER_29_449 vssd1 vccd1 vssd1 vccd1 X2_sky130_ef_sc_hd__decap_40_12
XFILLER_84_533 vssd1 vccd1 vssd1 vccd1 X2_sky130_ef_sc_hd__decap_40_12
XFILLER_71_205 vssd1 vccd1 vssd1 vccd1 X2_sky130_ef_sc_hd__decap_40_12
XFILLER_37_493 vssd1 vccd1 vccd1 vssd1 X2_sky130_fd_sc_hd__fill_8
XFILLER_71_249 vssd1 vccd1 vssd1 vccd1 X2_sky130_ef_sc_hd__decap_40_12
XFILLER_24_121 vssd1 vccd1 vssd1 vccd1 X2_sky130_ef_sc_hd__decap_40_12
XFILLER_52_441 vssd1 vccd1 vssd1 vccd1 X2_sky130_ef_sc_hd__decap_40_12
XFILLER_12_305 vssd1 vccd1 vccd1 vssd1 X2_sky130_fd_sc_hd__fill_2
XFILLER_24_165 vssd1 vccd1 vssd1 vccd1 X2_sky130_ef_sc_hd__decap_40_12
XFILLER_8_309 vssd1 vccd1 vssd1 vccd1 X2_sky130_ef_sc_hd__decap_40_12
XTAP_TAPCELL_ROW_76_1051 vccd1 vssd1 X2_sky130_fd_sc_hd__tapvpwrvgnd_1
XFILLER_79_305 vssd1 vccd1 vssd1 vccd1 X2_sky130_ef_sc_hd__decap_40_12
XFILLER_97_69 vssd1 vccd1 vssd1 vccd1 X2_sky130_ef_sc_hd__decap_40_12
XFILLER_79_349 vssd1 vccd1 vssd1 vccd1 X2_sky130_ef_sc_hd__decap_40_12
XFILLER_87_382 vssd1 vccd1 vccd1 vssd1 X2_sky130_fd_sc_hd__fill_8
XFILLER_87_393 vssd1 vccd1 vssd1 vccd1 X2_sky130_ef_sc_hd__decap_40_12
XFILLER_101_181 vssd1 vccd1 vssd1 vccd1 X2_sky130_ef_sc_hd__decap_40_12
XANTENNA_input28_A wbs_dat_i[14] vssd1 vccd1 vccd1 vssd1 X2_sky130_fd_sc_hd__diode_2
XFILLER_47_246 vccd1 vssd1 vccd1 vssd1 X2_sky130_fd_sc_hd__fill_1
XFILLER_62_205 vccd1 vssd1 vccd1 vssd1 X2_sky130_fd_sc_hd__fill_1
XFILLER_47_279 vccd1 vssd1 vccd1 vssd1 X2_sky130_fd_sc_hd__fill_1
XFILLER_47_257 vssd1 vccd1 vssd1 vccd1 X2_sky130_ef_sc_hd__decap_40_12
XTAP_TAPCELL_ROW_87_1180 vccd1 vssd1 X2_sky130_fd_sc_hd__tapvpwrvgnd_1
XFILLER_90_525 vssd1 vccd1 vccd1 vssd1 X2_sky130_fd_sc_hd__fill_4
XFILLER_90_569 vssd1 vccd1 vssd1 vccd1 X2_sky130_ef_sc_hd__decap_40_12
XFILLER_62_249 vssd1 vccd1 vccd1 vssd1 X2_sky130_fd_sc_hd__fill_2
XFILLER_15_165 vssd1 vccd1 vccd1 vssd1 X2_sky130_fd_sc_hd__fill_2
XTAP_TAPCELL_ROW_13_366 vccd1 vssd1 X2_sky130_fd_sc_hd__tapvpwrvgnd_1
XFILLER_62_83 vccd1 vssd1 vccd1 vssd1 X2_sky130_fd_sc_hd__fill_1
XTAP_TAPCELL_ROW_41_675 vccd1 vssd1 X2_sky130_fd_sc_hd__tapvpwrvgnd_1
XFILLER_11_393 vssd1 vccd1 vssd1 vccd1 X2_sky130_ef_sc_hd__decap_40_12
XFILLER_97_113 vssd1 vccd1 vssd1 vccd1 X2_sky130_ef_sc_hd__decap_40_12
XFILLER_23_3 vssd1 vccd1 vssd1 vccd1 X2_sky130_ef_sc_hd__decap_40_12
XANTENNA__279__S _289_/S vssd1 vccd1 vccd1 vssd1 X2_sky130_fd_sc_hd__diode_2
XFILLER_66_533 vssd1 vccd1 vssd1 vccd1 X2_sky130_ef_sc_hd__decap_40_12
XFILLER_26_419 vccd1 vssd1 vccd1 vssd1 X2_sky130_fd_sc_hd__fill_1
XFILLER_93_352 vssd1 vccd1 vssd1 vccd1 X2_sky130_ef_sc_hd__decap_40_12
XFILLER_81_503 vccd1 vssd1 vccd1 vssd1 X2_sky130_fd_sc_hd__fill_1
XTAP_TAPCELL_ROW_49_764 vccd1 vssd1 X2_sky130_fd_sc_hd__tapvpwrvgnd_1
XFILLER_53_249 vssd1 vccd1 vccd1 vssd1 X2_sky130_fd_sc_hd__fill_8
XFILLER_34_485 vssd1 vccd1 vssd1 vccd1 X2_sky130_ef_sc_hd__decap_40_12
XFILLER_21_113 vssd1 vccd1 vssd1 vccd1 X2_sky130_ef_sc_hd__decap_40_12
XFILLER_61_293 vssd1 vccd1 vssd1 vccd1 X2_sky130_ef_sc_hd__decap_40_12
XFILLER_1_529 vssd1 vccd1 vssd1 vccd1 X2_sky130_ef_sc_hd__decap_40_12
XFILLER_69_393 vssd1 vccd1 vssd1 vccd1 X2_sky130_ef_sc_hd__decap_40_12
XFILLER_29_279 vccd1 vssd1 vccd1 vssd1 X2_sky130_fd_sc_hd__fill_1
XFILLER_84_363 vccd1 vssd1 vccd1 vssd1 X2_sky130_fd_sc_hd__fill_1
XFILLER_84_341 vssd1 vccd1 vccd1 vssd1 X2_sky130_fd_sc_hd__fill_2
XFILLER_83_27 vssd1 vccd1 vssd1 vccd1 X2_sky130_ef_sc_hd__decap_40_12
XFILLER_72_525 vssd1 vccd1 vccd1 vssd1 X2_sky130_fd_sc_hd__fill_4
XFILLER_44_238 vssd1 vccd1 vssd1 vccd1 X2_sky130_ef_sc_hd__decap_40_12
XFILLER_25_441 vssd1 vccd1 vccd1 vssd1 X2_sky130_fd_sc_hd__fill_4
XFILLER_72_569 vssd1 vccd1 vssd1 vccd1 X2_sky130_ef_sc_hd__decap_40_12
XFILLER_16_65 vssd1 vccd1 vssd1 vccd1 X2_sky130_ef_sc_hd__decap_40_12
XFILLER_25_485 vssd1 vccd1 vssd1 vccd1 X2_sky130_ef_sc_hd__decap_40_12
XFILLER_40_433 vssd1 vccd1 vssd1 vccd1 X2_sky130_ef_sc_hd__decap_40_12
XFILLER_52_282 vssd1 vccd1 vssd1 vccd1 X2_sky130_ef_sc_hd__decap_40_12
XFILLER_40_477 vssd1 vccd1 vssd1 vccd1 X2_sky130_ef_sc_hd__decap_40_12
XFILLER_8_139 vccd1 vssd1 vccd1 vssd1 X2_sky130_fd_sc_hd__fill_1
XTAP_TAPCELL_ROW_10_325 vccd1 vssd1 X2_sky130_fd_sc_hd__tapvpwrvgnd_1
XFILLER_32_53 vssd1 vccd1 vssd1 vccd1 X2_sky130_ef_sc_hd__decap_40_12
XFILLER_32_97 vssd1 vccd1 vssd1 vccd1 X2_sky130_ef_sc_hd__decap_40_12
XFILLER_4_301 vssd1 vccd1 vccd1 vssd1 X2_sky130_fd_sc_hd__fill_4
XFILLER_4_345 vssd1 vccd1 vssd1 vccd1 X2_sky130_ef_sc_hd__decap_40_12
XFILLER_4_389 vssd1 vccd1 vssd1 vccd1 X2_sky130_ef_sc_hd__decap_40_12
XFILLER_79_113 vssd1 vccd1 vssd1 vccd1 X2_sky130_ef_sc_hd__decap_40_12
XFILLER_0_573 vssd1 vccd1 vssd1 vccd1 X2_sky130_ef_sc_hd__decap_40_12
XFILLER_95_617 vssd1 vccd1 vccd1 vssd1 X2_sky130_fd_sc_hd__fill_8
XFILLER_48_533 vssd1 vccd1 vccd1 vssd1 X2_sky130_fd_sc_hd__fill_8
XFILLER_63_503 vccd1 vssd1 vccd1 vssd1 X2_sky130_fd_sc_hd__fill_1
XTAP_TAPCELL_ROW_18_414 vccd1 vssd1 X2_sky130_fd_sc_hd__tapvpwrvgnd_1
XFILLER_35_216 vssd1 vccd1 vccd1 vssd1 X2_sky130_fd_sc_hd__fill_2
XFILLER_75_385 vssd1 vccd1 vccd1 vssd1 X2_sky130_fd_sc_hd__fill_4
XTAP_TAPCELL_ROW_46_723 vccd1 vssd1 X2_sky130_fd_sc_hd__tapvpwrvgnd_1
XFILLER_90_377 vssd1 vccd1 vssd1 vccd1 X2_sky130_ef_sc_hd__decap_40_12
XFILLER_73_93 vssd1 vccd1 vssd1 vccd1 X2_sky130_ef_sc_hd__decap_40_12
XFILLER_43_293 vssd1 vccd1 vssd1 vccd1 X2_sky130_ef_sc_hd__decap_40_12
XFILLER_7_161 vssd1 vccd1 vccd1 vssd1 X2_sky130_fd_sc_hd__fill_4
XPHY_EDGE_ROW_9_Right_9 vccd1 vssd1 vccd1 vssd1 X2_sky130_fd_sc_hd__decap_3
XTAP_TAPCELL_ROW_96_1279 vccd1 vssd1 X2_sky130_fd_sc_hd__tapvpwrvgnd_1
XFILLER_98_477 vssd1 vccd1 vssd1 vccd1 X2_sky130_ef_sc_hd__decap_40_12
XFILLER_85_105 vssd1 vccd1 vccd1 vssd1 X2_sky130_fd_sc_hd__fill_4
XFILLER_85_149 vssd1 vccd1 vssd1 vccd1 X2_sky130_ef_sc_hd__decap_40_12
XFILLER_66_363 vccd1 vssd1 vccd1 vssd1 X2_sky130_fd_sc_hd__fill_1
XFILLER_26_249 vssd1 vccd1 vccd1 vssd1 X2_sky130_fd_sc_hd__fill_2
XFILLER_93_193 vssd1 vccd1 vssd1 vccd1 X2_sky130_ef_sc_hd__decap_40_12
XFILLER_81_333 vssd1 vccd1 vccd1 vssd1 X2_sky130_fd_sc_hd__fill_2
XFILLER_22_433 vssd1 vccd1 vssd1 vccd1 X2_sky130_ef_sc_hd__decap_40_12
XFILLER_22_477 vssd1 vccd1 vssd1 vccd1 X2_sky130_ef_sc_hd__decap_40_12
XFILLER_5_109 vssd1 vccd1 vccd1 vssd1 X2_sky130_fd_sc_hd__fill_2
XFILLER_78_27 vccd1 vssd1 vccd1 vssd1 X2_sky130_fd_sc_hd__fill_1
XTAP_TAPCELL_ROW_73_1021 vccd1 vssd1 X2_sky130_fd_sc_hd__tapvpwrvgnd_1
XFILLER_1_337 vccd1 vssd1 vccd1 vssd1 X2_sky130_fd_sc_hd__fill_1
XFILLER_1_348 vssd1 vccd1 vccd1 vssd1 X2_sky130_fd_sc_hd__fill_2
XANTENNA__501__A _517_/A vssd1 vccd1 vccd1 vssd1 X2_sky130_fd_sc_hd__diode_2
XFILLER_77_617 vssd1 vccd1 vccd1 vssd1 X2_sky130_fd_sc_hd__fill_8
XFILLER_94_15 vssd1 vccd1 vssd1 vccd1 X2_sky130_ef_sc_hd__decap_40_12
X_600_ vccd1 vssd1 vccd1 vssd1 _600_/Q _520_/Y _600_/D _601_/CLK X2_sky130_fd_sc_hd__dfstp_1
XFILLER_57_330 vssd1 vccd1 vccd1 vssd1 X2_sky130_fd_sc_hd__fill_4
XFILLER_45_503 vccd1 vssd1 vccd1 vssd1 X2_sky130_fd_sc_hd__fill_1
XFILLER_17_205 vssd1 vccd1 vssd1 vccd1 X2_sky130_ef_sc_hd__decap_40_12
X_531_ vssd1 vccd1 vccd1 vssd1 _608_/CLK _531_/D _451_/Y hold6/A X2_sky130_fd_sc_hd__dfrtp_1
XFILLER_17_249 vssd1 vccd1 vssd1 vccd1 X2_sky130_ef_sc_hd__decap_40_12
XFILLER_84_193 vssd1 vccd1 vccd1 vssd1 X2_sky130_fd_sc_hd__fill_2
XFILLER_72_333 vssd1 vccd1 vssd1 vccd1 X2_sky130_ef_sc_hd__decap_40_12
XFILLER_32_219 vssd1 vccd1 vccd1 vssd1 X2_sky130_fd_sc_hd__fill_4
XFILLER_72_377 vssd1 vccd1 vssd1 vccd1 X2_sky130_ef_sc_hd__decap_40_12
X_462_ vccd1 vssd1 vccd1 vssd1 _462_/Y _473_/A X2_sky130_fd_sc_hd__inv_2
XFILLER_25_293 vssd1 vccd1 vssd1 vccd1 X2_sky130_ef_sc_hd__decap_40_12
X_393_ vssd1 vccd1 vssd1 vccd1 _362_/X _413_/A _393_/C _411_/A _394_/B X2_sky130_fd_sc_hd__and4bb_1
XFILLER_40_230 vssd1 vccd1 vssd1 vccd1 X2_sky130_ef_sc_hd__decap_40_12
XTAP_TAPCELL_ROW_23_472 vccd1 vssd1 X2_sky130_fd_sc_hd__tapvpwrvgnd_1
XFILLER_40_285 vssd1 vccd1 vccd1 vssd1 X2_sky130_fd_sc_hd__fill_2
XTAP_TAPCELL_ROW_51_781 vccd1 vssd1 X2_sky130_fd_sc_hd__tapvpwrvgnd_1
XFILLER_4_153 vssd1 vccd1 vssd1 vccd1 X2_sky130_ef_sc_hd__decap_40_12
XFILLER_4_197 vssd1 vccd1 vssd1 vccd1 X2_sky130_ef_sc_hd__decap_40_12
XFILLER_67_105 vssd1 vccd1 vccd1 vssd1 X2_sky130_fd_sc_hd__fill_4
XFILLER_95_447 vccd1 vssd1 vccd1 vssd1 X2_sky130_fd_sc_hd__fill_1
XFILLER_67_149 vssd1 vccd1 vssd1 vccd1 X2_sky130_ef_sc_hd__decap_40_12
XFILLER_83_609 vssd1 vccd1 vccd1 vssd1 X2_sky130_fd_sc_hd__fill_4
XTAP_TAPCELL_ROW_59_870 vccd1 vssd1 X2_sky130_fd_sc_hd__tapvpwrvgnd_1
XFILLER_48_374 vssd1 vccd1 vssd1 vccd1 X2_sky130_ef_sc_hd__decap_40_12
XFILLER_48_363 vccd1 vssd1 vccd1 vssd1 X2_sky130_fd_sc_hd__fill_1
XFILLER_90_141 vssd1 vccd1 vssd1 vccd1 X2_sky130_ef_sc_hd__decap_40_12
XFILLER_84_81 vssd1 vccd1 vccd1 vssd1 X2_sky130_fd_sc_hd__fill_2
XFILLER_75_193 vssd1 vccd1 vssd1 vccd1 X2_sky130_ef_sc_hd__decap_40_12
XFILLER_51_517 vssd1 vccd1 vssd1 vccd1 X2_sky130_ef_sc_hd__decap_40_12
XFILLER_44_591 vccd1 vssd1 vccd1 vssd1 X2_sky130_fd_sc_hd__fill_1
XFILLER_90_3 vssd1 vccd1 vssd1 vccd1 X2_sky130_ef_sc_hd__decap_40_12
XANTENNA__292__S _299_/S vssd1 vccd1 vccd1 vssd1 X2_sky130_fd_sc_hd__diode_2
XFILLER_59_617 vccd1 vssd1 vccd1 vssd1 X2_sky130_fd_sc_hd__fill_1
XANTENNA__551__CLK _553_/CLK vssd1 vccd1 vccd1 vssd1 X2_sky130_fd_sc_hd__diode_2
XFILLER_86_469 vssd1 vccd1 vccd1 vssd1 X2_sky130_fd_sc_hd__fill_4
XFILLER_74_609 vssd1 vccd1 vccd1 vssd1 X2_sky130_fd_sc_hd__fill_2
XFILLER_27_503 vccd1 vssd1 vccd1 vssd1 X2_sky130_fd_sc_hd__fill_1
XFILLER_39_374 vssd1 vccd1 vssd1 vccd1 X2_sky130_ef_sc_hd__decap_40_12
XFILLER_66_193 vssd1 vccd1 vccd1 vssd1 X2_sky130_fd_sc_hd__fill_2
XFILLER_64_29 vssd1 vccd1 vssd1 vccd1 X2_sky130_ef_sc_hd__decap_40_12
XFILLER_54_377 vssd1 vccd1 vccd1 vssd1 X2_sky130_fd_sc_hd__fill_4
XFILLER_35_580 vssd1 vccd1 vssd1 vccd1 X2_sky130_ef_sc_hd__decap_40_12
XFILLER_10_469 vssd1 vccd1 vccd1 vssd1 X2_sky130_fd_sc_hd__fill_4
XFILLER_13_55 vccd1 vssd1 vccd1 vssd1 X2_sky130_fd_sc_hd__fill_1
XTAP_TAPCELL_ROW_20_442 vccd1 vssd1 X2_sky130_fd_sc_hd__tapvpwrvgnd_1
XFILLER_89_15 vssd1 vccd1 vssd1 vccd1 X2_sky130_ef_sc_hd__decap_40_12
XFILLER_2_613 vssd1 vccd1 vssd1 vccd1 X2_sky130_ef_sc_hd__decap_40_12
XFILLER_1_167 vccd1 vssd1 vccd1 vssd1 X2_sky130_fd_sc_hd__fill_1
XFILLER_49_105 vssd1 vccd1 vccd1 vssd1 X2_sky130_fd_sc_hd__fill_4
XFILLER_89_285 vssd1 vccd1 vccd1 vssd1 X2_sky130_fd_sc_hd__fill_2
XFILLER_77_447 vccd1 vssd1 vccd1 vssd1 X2_sky130_fd_sc_hd__fill_1
XFILLER_38_41 vssd1 vccd1 vssd1 vccd1 X2_sky130_ef_sc_hd__decap_40_12
XFILLER_49_149 vssd1 vccd1 vssd1 vccd1 X2_sky130_ef_sc_hd__decap_40_12
XFILLER_18_525 vssd1 vccd1 vccd1 vssd1 X2_sky130_fd_sc_hd__fill_4
XFILLER_38_85 vssd1 vccd1 vssd1 vccd1 X2_sky130_ef_sc_hd__decap_40_12
XFILLER_92_417 vssd1 vccd1 vccd1 vssd1 X2_sky130_fd_sc_hd__fill_2
XFILLER_45_311 vccd1 vssd1 vccd1 vssd1 X2_sky130_fd_sc_hd__fill_1
XFILLER_18_569 vssd1 vccd1 vssd1 vccd1 X2_sky130_ef_sc_hd__decap_40_12
XTAP_TAPCELL_ROW_28_531 vccd1 vssd1 X2_sky130_fd_sc_hd__tapvpwrvgnd_1
XFILLER_57_193 vssd1 vccd1 vssd1 vccd1 X2_sky130_ef_sc_hd__decap_40_12
XTAP_TAPCELL_ROW_56_840 vccd1 vssd1 X2_sky130_fd_sc_hd__tapvpwrvgnd_1
XANTENNA_input10_A adc_data_in[7] vssd1 vccd1 vccd1 vssd1 X2_sky130_fd_sc_hd__diode_2
X_514_ vccd1 vssd1 vccd1 vssd1 _514_/Y _517_/A X2_sky130_fd_sc_hd__inv_2
XFILLER_72_141 vssd1 vccd1 vssd1 vccd1 X2_sky130_ef_sc_hd__decap_40_12
XFILLER_60_336 vssd1 vccd1 vccd1 vssd1 X2_sky130_fd_sc_hd__fill_4
X_445_ vssd1 vccd1 vccd1 vssd1 _445_/X _297_/A0 _440_/Y hold53/X _444_/X X2_sky130_fd_sc_hd__o2bb2a_1
XFILLER_41_561 vssd1 vccd1 vccd1 vssd1 X2_sky130_fd_sc_hd__fill_2
XFILLER_9_223 vccd1 vssd1 vccd1 vssd1 X2_sky130_fd_sc_hd__fill_1
X_376_ vssd1 vccd1 vssd1 vccd1 _374_/X _373_/A _377_/B _375_/Y X2_sky130_fd_sc_hd__a21oi_2
XFILLER_41_572 vssd1 vccd1 vccd1 vssd1 X2_sky130_fd_sc_hd__fill_2
XFILLER_70_83 vccd1 vssd1 vccd1 vssd1 X2_sky130_fd_sc_hd__fill_1
XFILLER_5_473 vssd1 vccd1 vssd1 vccd1 X2_sky130_ef_sc_hd__decap_40_12
XTAP_TAPCELL_ROW_93_1238 vccd1 vssd1 X2_sky130_fd_sc_hd__tapvpwrvgnd_1
XANTENNA__574__CLK _607_/CLK vssd1 vccd1 vccd1 vssd1 X2_sky130_fd_sc_hd__diode_2
XFILLER_79_81 vssd1 vccd1 vssd1 vccd1 X2_sky130_ef_sc_hd__decap_40_12
XFILLER_68_469 vssd1 vccd1 vccd1 vssd1 X2_sky130_fd_sc_hd__fill_4
XFILLER_95_277 vssd1 vccd1 vccd1 vssd1 X2_sky130_fd_sc_hd__fill_2
XFILLER_83_417 vssd1 vccd1 vssd1 vccd1 X2_sky130_ef_sc_hd__decap_40_12
XANTENNA__287__S _289_/S vssd1 vccd1 vccd1 vssd1 X2_sky130_fd_sc_hd__diode_2
XFILLER_36_333 vssd1 vccd1 vssd1 vccd1 X2_sky130_ef_sc_hd__decap_40_12
XFILLER_36_377 vssd1 vccd1 vssd1 vccd1 X2_sky130_ef_sc_hd__decap_40_12
XFILLER_91_461 vssd1 vccd1 vssd1 vccd1 X2_sky130_ef_sc_hd__decap_40_12
XFILLER_36_399 vccd1 vssd1 vccd1 vssd1 X2_sky130_fd_sc_hd__fill_1
XTAP_TAPCELL_ROW_34_589 vccd1 vssd1 X2_sky130_fd_sc_hd__tapvpwrvgnd_1
XTAP_TAPCELL_ROW_62_898 vccd1 vssd1 X2_sky130_fd_sc_hd__tapvpwrvgnd_1
XFILLER_99_561 vssd1 vccd1 vssd1 vccd1 X2_sky130_ef_sc_hd__decap_40_12
XFILLER_101_533 vssd1 vccd1 vccd1 vssd1 X2_sky130_fd_sc_hd__fill_8
XFILLER_59_447 vccd1 vssd1 vccd1 vssd1 X2_sky130_fd_sc_hd__fill_1
XFILLER_86_233 vssd1 vccd1 vssd1 vccd1 X2_sky130_ef_sc_hd__decap_40_12
XANTENNA_input2_A adc_data_in[10] vssd1 vccd1 vccd1 vssd1 X2_sky130_fd_sc_hd__diode_2
XFILLER_47_609 vccd1 vssd1 vccd1 vssd1 X2_sky130_fd_sc_hd__fill_1
XFILLER_86_277 vssd1 vccd1 vssd1 vccd1 X2_sky130_ef_sc_hd__decap_40_12
XFILLER_75_39 vssd1 vccd1 vssd1 vccd1 X2_sky130_ef_sc_hd__decap_40_12
XFILLER_74_417 vssd1 vccd1 vccd1 vssd1 X2_sky130_fd_sc_hd__fill_2
XFILLER_27_333 vssd1 vccd1 vccd1 vssd1 X2_sky130_fd_sc_hd__fill_2
XFILLER_39_193 vssd1 vccd1 vssd1 vccd1 X2_sky130_ef_sc_hd__decap_40_12
XFILLER_15_517 vssd1 vccd1 vssd1 vccd1 X2_sky130_ef_sc_hd__decap_40_12
XFILLER_54_141 vssd1 vccd1 vssd1 vccd1 X2_sky130_ef_sc_hd__decap_40_12
XFILLER_91_27 vssd1 vccd1 vssd1 vccd1 X2_sky130_ef_sc_hd__decap_40_12
XFILLER_23_561 vssd1 vccd1 vssd1 vccd1 X2_sky130_ef_sc_hd__decap_40_12
XFILLER_24_65 vssd1 vccd1 vssd1 vccd1 X2_sky130_ef_sc_hd__decap_40_12
XFILLER_10_233 vssd1 vccd1 vssd1 vccd1 X2_sky130_ef_sc_hd__decap_40_12
XFILLER_10_277 vssd1 vccd1 vssd1 vccd1 X2_sky130_ef_sc_hd__decap_40_12
XFILLER_40_53 vssd1 vccd1 vssd1 vccd1 X2_sky130_ef_sc_hd__decap_40_12
XFILLER_40_97 vssd1 vccd1 vssd1 vccd1 X2_sky130_ef_sc_hd__decap_40_12
XTAP_TAPCELL_ROW_79_1093 vccd1 vssd1 X2_sky130_fd_sc_hd__tapvpwrvgnd_1
XFILLER_2_421 vssd1 vccd1 vssd1 vccd1 X2_sky130_ef_sc_hd__decap_40_12
XFILLER_49_51 vssd1 vccd1 vccd1 vssd1 X2_sky130_fd_sc_hd__fill_4
XTAP_TAPCELL_ROW_5_270 vccd1 vssd1 X2_sky130_fd_sc_hd__tapvpwrvgnd_1
XFILLER_77_277 vssd1 vccd1 vccd1 vssd1 X2_sky130_fd_sc_hd__fill_2
XFILLER_65_417 vssd1 vccd1 vssd1 vccd1 X2_sky130_ef_sc_hd__decap_40_12
XFILLER_1_69 vssd1 vccd1 vssd1 vccd1 X2_sky130_ef_sc_hd__decap_40_12
XFILLER_18_333 vssd1 vccd1 vssd1 vccd1 X2_sky130_ef_sc_hd__decap_40_12
XANTENNA_input13_X input13/X vssd1 vccd1 vccd1 vssd1 X2_sky130_fd_sc_hd__diode_2
XFILLER_18_377 vssd1 vccd1 vssd1 vccd1 X2_sky130_ef_sc_hd__decap_40_12
XFILLER_92_269 vssd1 vccd1 vccd1 vssd1 X2_sky130_fd_sc_hd__fill_2
XFILLER_73_461 vssd1 vccd1 vssd1 vccd1 X2_sky130_ef_sc_hd__decap_40_12
XFILLER_33_369 vccd1 vssd1 vccd1 vssd1 X2_sky130_fd_sc_hd__fill_1
XFILLER_60_133 vssd1 vccd1 vccd1 vssd1 X2_sky130_fd_sc_hd__fill_4
XFILLER_60_177 vssd1 vccd1 vssd1 vccd1 X2_sky130_ef_sc_hd__decap_40_12
X_428_ vccd1 vssd1 vccd1 vssd1 _549_/D _550_/D _428_/X _427_/X _547_/D _551_/D X2_sky130_fd_sc_hd__a221o_1
XTAP_TAPCELL_ROW_31_559 vccd1 vssd1 X2_sky130_fd_sc_hd__tapvpwrvgnd_1
XFILLER_81_93 vssd1 vccd1 vssd1 vccd1 X2_sky130_ef_sc_hd__decap_40_12
XFILLER_41_391 vccd1 vssd1 vccd1 vssd1 X2_sky130_fd_sc_hd__fill_1
X_359_ vccd1 vssd1 vssd1 vccd1 _550_/Q _535_/Q _359_/Y X2_sky130_fd_sc_hd__nand2b_1
XFILLER_53_3 vssd1 vccd1 vssd1 vccd1 X2_sky130_ef_sc_hd__decap_40_12
XFILLER_5_281 vssd1 vccd1 vssd1 vccd1 X2_sky130_ef_sc_hd__decap_40_12
XFILLER_96_531 vccd1 vssd1 vccd1 vssd1 X2_sky130_fd_sc_hd__fill_1
XFILLER_29_609 vssd1 vccd1 vccd1 vssd1 X2_sky130_fd_sc_hd__fill_4
XFILLER_68_233 vssd1 vccd1 vssd1 vccd1 X2_sky130_ef_sc_hd__decap_40_12
Xinput2 vssd1 vccd1 _540_/D adc_data_in[10] vccd1 vssd1 X2_sky130_fd_sc_hd__buf_1
XFILLER_56_417 vssd1 vccd1 vccd1 vssd1 X2_sky130_fd_sc_hd__fill_2
XTAP_TAPCELL_ROW_39_648 vccd1 vssd1 X2_sky130_fd_sc_hd__tapvpwrvgnd_1
XFILLER_83_225 vssd1 vccd1 vssd1 vccd1 X2_sky130_ef_sc_hd__decap_40_12
XTAP_TAPCELL_ROW_67_957 vccd1 vssd1 X2_sky130_fd_sc_hd__tapvpwrvgnd_1
XFILLER_36_141 vssd1 vccd1 vssd1 vccd1 X2_sky130_ef_sc_hd__decap_40_12
XFILLER_52_601 vssd1 vccd1 vccd1 vssd1 X2_sky130_fd_sc_hd__fill_8
XFILLER_101_15 vssd1 vccd1 vssd1 vccd1 X2_sky130_ef_sc_hd__decap_40_12
XFILLER_51_111 vccd1 vssd1 vccd1 vssd1 X2_sky130_fd_sc_hd__fill_1
XFILLER_91_291 vssd1 vccd1 vccd1 vssd1 X2_sky130_fd_sc_hd__fill_2
XFILLER_20_531 vccd1 vssd1 vccd1 vssd1 X2_sky130_fd_sc_hd__fill_1
XFILLER_86_27 vccd1 vssd1 vccd1 vssd1 X2_sky130_fd_sc_hd__fill_1
XFILLER_87_553 vssd1 vccd1 vccd1 vssd1 X2_sky130_fd_sc_hd__fill_4
XFILLER_87_597 vssd1 vccd1 vssd1 vccd1 X2_sky130_ef_sc_hd__decap_40_12
XFILLER_101_352 vccd1 vssd1 vccd1 vssd1 X2_sky130_fd_sc_hd__fill_1
XFILLER_59_277 vssd1 vccd1 vccd1 vssd1 X2_sky130_fd_sc_hd__fill_2
XFILLER_47_428 vssd1 vccd1 vccd1 vssd1 X2_sky130_fd_sc_hd__fill_4
XTAP_TAPCELL_ROW_2_240 vccd1 vssd1 X2_sky130_fd_sc_hd__tapvpwrvgnd_1
XANTENNA_fanout60_A _521_/A vssd1 vccd1 vccd1 vssd1 X2_sky130_fd_sc_hd__diode_2
XFILLER_101_385 vssd1 vccd1 vccd1 vssd1 X2_sky130_fd_sc_hd__fill_4
XFILLER_55_461 vssd1 vccd1 vssd1 vccd1 X2_sky130_ef_sc_hd__decap_40_12
XFILLER_42_133 vssd1 vccd1 vccd1 vssd1 X2_sky130_fd_sc_hd__fill_4
XFILLER_70_475 vccd1 vssd1 vccd1 vssd1 X2_sky130_fd_sc_hd__fill_1
XFILLER_42_177 vssd1 vccd1 vssd1 vccd1 X2_sky130_ef_sc_hd__decap_40_12
XFILLER_23_391 vccd1 vssd1 vccd1 vssd1 X2_sky130_fd_sc_hd__fill_1
XFILLER_11_553 vssd1 vccd1 vccd1 vssd1 X2_sky130_fd_sc_hd__fill_4
XFILLER_7_557 vssd1 vccd1 vccd1 vssd1 X2_sky130_fd_sc_hd__fill_2
XFILLER_11_597 vssd1 vccd1 vssd1 vccd1 X2_sky130_ef_sc_hd__decap_40_12
XTAP_TAPCELL_ROW_90_1208 vccd1 vssd1 X2_sky130_fd_sc_hd__tapvpwrvgnd_1
XFILLER_2_251 vccd1 vssd1 vccd1 vssd1 X2_sky130_fd_sc_hd__fill_1
XFILLER_97_317 vccd1 vssd1 vccd1 vssd1 X2_sky130_fd_sc_hd__fill_1
XANTENNA__294__A0 _448_/A1 vssd1 vccd1 vccd1 vssd1 X2_sky130_fd_sc_hd__diode_2
XFILLER_78_531 vccd1 vssd1 vccd1 vssd1 X2_sky130_fd_sc_hd__fill_1
XFILLER_38_428 vssd1 vccd1 vccd1 vssd1 X2_sky130_fd_sc_hd__fill_4
XFILLER_93_501 vssd1 vccd1 vccd1 vssd1 X2_sky130_fd_sc_hd__fill_2
XFILLER_65_225 vssd1 vccd1 vssd1 vccd1 X2_sky130_ef_sc_hd__decap_40_12
XFILLER_18_141 vssd1 vccd1 vssd1 vccd1 X2_sky130_ef_sc_hd__decap_40_12
XFILLER_34_601 vssd1 vccd1 vccd1 vssd1 X2_sky130_fd_sc_hd__fill_2
XTAP_TAPCELL_ROW_36_618 vccd1 vssd1 X2_sky130_fd_sc_hd__tapvpwrvgnd_1
XTAP_TAPCELL_ROW_64_927 vccd1 vssd1 X2_sky130_fd_sc_hd__tapvpwrvgnd_1
XFILLER_53_409 vssd1 vccd1 vssd1 vccd1 X2_sky130_ef_sc_hd__decap_40_12
XFILLER_33_111 vccd1 vssd1 vccd1 vssd1 X2_sky130_fd_sc_hd__fill_1
XFILLER_92_81 vssd1 vccd1 vccd1 vssd1 X2_sky130_fd_sc_hd__fill_2
XFILLER_21_317 vssd1 vccd1 vssd1 vccd1 X2_sky130_ef_sc_hd__decap_40_12
XFILLER_61_497 vssd1 vccd1 vccd1 vssd1 X2_sky130_fd_sc_hd__fill_4
XTAP_TAPCELL_ROW_16_397 vccd1 vssd1 X2_sky130_fd_sc_hd__tapvpwrvgnd_1
XANTENNA__313__B _317_/B vssd1 vccd1 vccd1 vssd1 X2_sky130_fd_sc_hd__diode_2
XFILLER_69_553 vssd1 vccd1 vccd1 vssd1 X2_sky130_fd_sc_hd__fill_4
XFILLER_29_417 vssd1 vccd1 vssd1 vccd1 X2_sky130_ef_sc_hd__decap_40_12
XFILLER_84_501 vssd1 vccd1 vssd1 vccd1 X2_sky130_ef_sc_hd__decap_40_12
XFILLER_84_545 vssd1 vccd1 vssd1 vccd1 X2_sky130_ef_sc_hd__decap_40_12
XFILLER_84_589 vssd1 vccd1 vssd1 vccd1 X2_sky130_ef_sc_hd__decap_40_12
XFILLER_56_269 vssd1 vccd1 vccd1 vssd1 X2_sky130_fd_sc_hd__fill_2
XFILLER_44_409 vssd1 vccd1 vccd1 vssd1 X2_sky130_fd_sc_hd__fill_2
XFILLER_71_217 vssd1 vccd1 vccd1 vssd1 X2_sky130_fd_sc_hd__fill_4
XFILLER_24_133 vssd1 vccd1 vccd1 vssd1 X2_sky130_fd_sc_hd__fill_4
XFILLER_72_29 vssd1 vccd1 vssd1 vccd1 X2_sky130_ef_sc_hd__decap_40_12
XFILLER_52_453 vssd1 vccd1 vssd1 vccd1 X2_sky130_ef_sc_hd__decap_40_12
XFILLER_24_177 vssd1 vccd1 vssd1 vccd1 X2_sky130_ef_sc_hd__decap_40_12
XFILLER_20_361 vssd1 vccd1 vccd1 vssd1 X2_sky130_fd_sc_hd__fill_2
XFILLER_21_55 vccd1 vssd1 vccd1 vssd1 X2_sky130_fd_sc_hd__fill_1
XANTENNA__504__A _527_/A vssd1 vccd1 vccd1 vssd1 X2_sky130_fd_sc_hd__diode_2
XFILLER_97_15 vssd1 vccd1 vssd1 vccd1 X2_sky130_ef_sc_hd__decap_40_12
XTAP_TAPCELL_ROW_76_1052 vccd1 vssd1 X2_sky130_fd_sc_hd__tapvpwrvgnd_1
XFILLER_79_317 vssd1 vccd1 vssd1 vccd1 X2_sky130_ef_sc_hd__decap_40_12
XFILLER_94_309 vssd1 vccd1 vssd1 vccd1 X2_sky130_ef_sc_hd__decap_40_12
XFILLER_75_501 vssd1 vccd1 vccd1 vssd1 X2_sky130_fd_sc_hd__fill_2
XANTENNA_fanout63_X _517_/A vssd1 vccd1 vccd1 vssd1 X2_sky130_fd_sc_hd__diode_2
XFILLER_47_236 vssd1 vccd1 vccd1 vssd1 X2_sky130_fd_sc_hd__fill_2
XFILLER_47_225 vssd1 vccd1 vccd1 vssd1 X2_sky130_fd_sc_hd__fill_8
XFILLER_101_193 vssd1 vccd1 vccd1 vssd1 X2_sky130_fd_sc_hd__fill_2
XFILLER_75_589 vssd1 vccd1 vssd1 vccd1 X2_sky130_ef_sc_hd__decap_40_12
XFILLER_47_269 vssd1 vccd1 vccd1 vssd1 X2_sky130_fd_sc_hd__fill_2
XFILLER_46_41 vssd1 vccd1 vssd1 vccd1 X2_sky130_ef_sc_hd__decap_40_12
XFILLER_16_601 vssd1 vccd1 vssd1 vccd1 X2_sky130_ef_sc_hd__decap_40_12
XFILLER_46_85 vssd1 vccd1 vssd1 vccd1 X2_sky130_ef_sc_hd__decap_40_12
XFILLER_15_111 vccd1 vssd1 vccd1 vssd1 X2_sky130_fd_sc_hd__fill_1
XTAP_TAPCELL_ROW_87_1181 vccd1 vssd1 X2_sky130_fd_sc_hd__tapvpwrvgnd_1
XFILLER_31_615 vccd1 vssd1 vccd1 vssd1 X2_sky130_fd_sc_hd__fill_1
XTAP_TAPCELL_ROW_13_367 vccd1 vssd1 X2_sky130_fd_sc_hd__tapvpwrvgnd_1
XTAP_TAPCELL_ROW_41_676 vccd1 vssd1 X2_sky130_fd_sc_hd__tapvpwrvgnd_1
XFILLER_11_361 vssd1 vccd1 vssd1 vccd1 X2_sky130_ef_sc_hd__decap_40_12
XFILLER_7_57 vssd1 vccd1 vssd1 vccd1 X2_sky130_ef_sc_hd__decap_40_12
XFILLER_97_125 vssd1 vccd1 vssd1 vccd1 X2_sky130_ef_sc_hd__decap_40_12
XFILLER_87_81 vssd1 vccd1 vssd1 vccd1 X2_sky130_ef_sc_hd__decap_40_12
XFILLER_97_169 vssd1 vccd1 vssd1 vccd1 X2_sky130_ef_sc_hd__decap_40_12
XFILLER_78_361 vssd1 vccd1 vccd1 vssd1 X2_sky130_fd_sc_hd__fill_2
XFILLER_66_501 vssd1 vccd1 vssd1 vccd1 X2_sky130_ef_sc_hd__decap_40_12
XFILLER_16_3 vccd1 vssd1 vccd1 vssd1 X2_sky130_fd_sc_hd__fill_1
XFILLER_66_545 vssd1 vccd1 vssd1 vccd1 X2_sky130_ef_sc_hd__decap_40_12
XFILLER_93_364 vssd1 vccd1 vssd1 vccd1 X2_sky130_ef_sc_hd__decap_40_12
XFILLER_66_589 vssd1 vccd1 vssd1 vccd1 X2_sky130_ef_sc_hd__decap_40_12
XTAP_TAPCELL_ROW_49_754 vccd1 vssd1 X2_sky130_fd_sc_hd__tapvpwrvgnd_1
XFILLER_19_461 vssd1 vccd1 vssd1 vccd1 X2_sky130_ef_sc_hd__decap_40_12
XFILLER_53_206 vssd1 vccd1 vccd1 vssd1 X2_sky130_fd_sc_hd__fill_4
XANTENNA__295__S _299_/S vssd1 vccd1 vccd1 vssd1 X2_sky130_fd_sc_hd__diode_2
XFILLER_81_559 vccd1 vssd1 vccd1 vssd1 X2_sky130_fd_sc_hd__fill_1
XFILLER_34_475 vccd1 vssd1 vccd1 vssd1 X2_sky130_fd_sc_hd__fill_1
XFILLER_61_250 vssd1 vccd1 vssd1 vccd1 X2_sky130_ef_sc_hd__decap_40_12
XFILLER_21_125 vssd1 vccd1 vssd1 vccd1 X2_sky130_ef_sc_hd__decap_40_12
XFILLER_34_497 vssd1 vccd1 vssd1 vccd1 X2_sky130_ef_sc_hd__decap_40_12
XFILLER_21_169 vssd1 vccd1 vssd1 vccd1 X2_sky130_ef_sc_hd__decap_40_12
XFILLER_89_615 vccd1 vssd1 vccd1 vssd1 X2_sky130_fd_sc_hd__fill_1
XFILLER_76_309 vssd1 vccd1 vssd1 vccd1 X2_sky130_ef_sc_hd__decap_40_12
XFILLER_69_361 vssd1 vccd1 vssd1 vccd1 X2_sky130_ef_sc_hd__decap_40_12
XFILLER_57_501 vssd1 vccd1 vccd1 vssd1 X2_sky130_fd_sc_hd__fill_2
XFILLER_29_225 vssd1 vccd1 vssd1 vccd1 X2_sky130_ef_sc_hd__decap_40_12
XFILLER_29_269 vssd1 vccd1 vccd1 vssd1 X2_sky130_fd_sc_hd__fill_2
XFILLER_83_39 vssd1 vccd1 vssd1 vccd1 X2_sky130_ef_sc_hd__decap_40_12
XFILLER_13_615 vccd1 vssd1 vccd1 vssd1 X2_sky130_fd_sc_hd__fill_1
XFILLER_16_77 vssd1 vccd1 vccd1 vssd1 X2_sky130_fd_sc_hd__fill_4
XFILLER_25_497 vssd1 vccd1 vccd1 vssd1 X2_sky130_fd_sc_hd__fill_4
XFILLER_40_445 vssd1 vccd1 vssd1 vccd1 X2_sky130_ef_sc_hd__decap_40_12
XFILLER_80_581 vssd1 vccd1 vccd1 vssd1 X2_sky130_fd_sc_hd__fill_4
XFILLER_52_294 vssd1 vccd1 vssd1 vccd1 X2_sky130_ef_sc_hd__decap_40_12
XFILLER_32_65 vssd1 vccd1 vssd1 vccd1 X2_sky130_ef_sc_hd__decap_40_12
XFILLER_40_489 vssd1 vccd1 vssd1 vccd1 X2_sky130_ef_sc_hd__decap_40_12
XTAP_TAPCELL_ROW_10_326 vccd1 vssd1 X2_sky130_fd_sc_hd__tapvpwrvgnd_1
XFILLER_4_357 vssd1 vccd1 vccd1 vssd1 X2_sky130_fd_sc_hd__fill_4
XFILLER_79_125 vssd1 vccd1 vssd1 vccd1 X2_sky130_ef_sc_hd__decap_40_12
XANTENNA_input40_A wbs_we_i vssd1 vccd1 vccd1 vssd1 X2_sky130_fd_sc_hd__diode_2
XFILLER_79_169 vssd1 vccd1 vssd1 vccd1 X2_sky130_ef_sc_hd__decap_40_12
XFILLER_48_501 vssd1 vccd1 vccd1 vssd1 X2_sky130_fd_sc_hd__fill_2
XFILLER_0_585 vssd1 vccd1 vccd1 vssd1 X2_sky130_fd_sc_hd__fill_2
XFILLER_94_139 vccd1 vssd1 vccd1 vssd1 X2_sky130_fd_sc_hd__fill_1
XFILLER_57_51 vssd1 vccd1 vccd1 vssd1 X2_sky130_fd_sc_hd__fill_4
XTAP_TAPCELL_ROW_18_415 vccd1 vssd1 X2_sky130_fd_sc_hd__tapvpwrvgnd_1
XFILLER_35_206 vssd1 vccd1 vccd1 vssd1 X2_sky130_fd_sc_hd__fill_2
XFILLER_90_301 vssd1 vccd1 vccd1 vssd1 X2_sky130_fd_sc_hd__fill_2
XFILLER_48_589 vssd1 vccd1 vssd1 vccd1 X2_sky130_ef_sc_hd__decap_40_12
XTAP_TAPCELL_ROW_46_724 vccd1 vssd1 X2_sky130_fd_sc_hd__tapvpwrvgnd_1
XFILLER_90_334 vssd1 vccd1 vccd1 vssd1 X2_sky130_fd_sc_hd__fill_2
XFILLER_63_559 vccd1 vssd1 vccd1 vssd1 X2_sky130_fd_sc_hd__fill_1
XFILLER_16_475 vccd1 vssd1 vccd1 vssd1 X2_sky130_fd_sc_hd__fill_1
XFILLER_90_389 vssd1 vccd1 vssd1 vccd1 X2_sky130_ef_sc_hd__decap_40_12
XFILLER_43_261 vssd1 vccd1 vssd1 vccd1 X2_sky130_ef_sc_hd__decap_40_12
XFILLER_31_445 vssd1 vccd1 vccd1 vssd1 X2_sky130_fd_sc_hd__fill_2
XFILLER_39_501 vssd1 vccd1 vccd1 vssd1 X2_sky130_fd_sc_hd__fill_2
XFILLER_100_417 vssd1 vccd1 vccd1 vssd1 X2_sky130_fd_sc_hd__fill_2
XFILLER_98_489 vssd1 vccd1 vssd1 vccd1 X2_sky130_ef_sc_hd__decap_40_12
XFILLER_58_309 vccd1 vssd1 vccd1 vssd1 X2_sky130_fd_sc_hd__fill_1
XFILLER_93_161 vssd1 vccd1 vccd1 vssd1 X2_sky130_fd_sc_hd__fill_4
XFILLER_22_401 vssd1 vccd1 vssd1 vccd1 X2_sky130_ef_sc_hd__decap_40_12
XFILLER_81_389 vssd1 vccd1 vccd1 vssd1 X2_sky130_fd_sc_hd__fill_2
XFILLER_62_592 vssd1 vccd1 vccd1 vssd1 X2_sky130_fd_sc_hd__fill_2
XFILLER_22_445 vssd1 vccd1 vssd1 vccd1 X2_sky130_ef_sc_hd__decap_40_12
XFILLER_22_489 vssd1 vccd1 vssd1 vccd1 X2_sky130_ef_sc_hd__decap_40_12
XFILLER_1_305 vssd1 vccd1 vssd1 vccd1 X2_sky130_ef_sc_hd__decap_40_12
XTAP_TAPCELL_ROW_73_1022 vccd1 vssd1 X2_sky130_fd_sc_hd__tapvpwrvgnd_1
XFILLER_89_445 vssd1 vccd1 vccd1 vssd1 X2_sky130_fd_sc_hd__fill_2
XFILLER_94_27 vccd1 vssd1 vccd1 vssd1 X2_sky130_fd_sc_hd__fill_1
XFILLER_76_139 vccd1 vssd1 vccd1 vssd1 X2_sky130_fd_sc_hd__fill_1
XFILLER_91_109 vssd1 vccd1 vccd1 vssd1 X2_sky130_fd_sc_hd__fill_2
XFILLER_17_217 vssd1 vccd1 vccd1 vssd1 X2_sky130_fd_sc_hd__fill_4
X_530_ vssd1 vccd1 vccd1 vssd1 _608_/CLK _530_/D _263_/Y hold5/A X2_sky130_fd_sc_hd__dfrtp_2
XFILLER_72_301 vssd1 vccd1 vccd1 vssd1 X2_sky130_fd_sc_hd__fill_4
XFILLER_72_345 vssd1 vccd1 vssd1 vccd1 X2_sky130_ef_sc_hd__decap_40_12
XFILLER_32_209 vssd1 vccd1 vccd1 vssd1 X2_sky130_fd_sc_hd__fill_2
XTAP_TAPCELL_ROW_84_1140 vccd1 vssd1 X2_sky130_fd_sc_hd__tapvpwrvgnd_1
XFILLER_72_389 vssd1 vccd1 vssd1 vccd1 X2_sky130_ef_sc_hd__decap_40_12
X_461_ vccd1 vssd1 vccd1 vssd1 _461_/Y _521_/A X2_sky130_fd_sc_hd__inv_2
XFILLER_60_529 vssd1 vccd1 vccd1 vssd1 X2_sky130_fd_sc_hd__fill_2
XFILLER_25_261 vssd1 vccd1 vssd1 vccd1 X2_sky130_ef_sc_hd__decap_40_12
X_392_ vssd1 vccd1 _392_/X _392_/B _392_/A _392_/C vccd1 vssd1 X2_sky130_fd_sc_hd__and3_1
XFILLER_9_405 vssd1 vccd1 vssd1 vccd1 X2_sky130_ef_sc_hd__decap_40_12
XFILLER_13_445 vssd1 vccd1 vccd1 vssd1 X2_sky130_fd_sc_hd__fill_2
XFILLER_40_242 vssd1 vccd1 vccd1 vssd1 X2_sky130_fd_sc_hd__fill_8
XFILLER_40_253 vssd1 vccd1 vssd1 vccd1 X2_sky130_ef_sc_hd__decap_40_12
XFILLER_9_449 vssd1 vccd1 vssd1 vccd1 X2_sky130_ef_sc_hd__decap_40_12
XTAP_TAPCELL_ROW_23_473 vccd1 vssd1 X2_sky130_fd_sc_hd__tapvpwrvgnd_1
XTAP_TAPCELL_ROW_51_782 vccd1 vssd1 X2_sky130_fd_sc_hd__tapvpwrvgnd_1
XFILLER_4_121 vssd1 vccd1 vssd1 vccd1 X2_sky130_ef_sc_hd__decap_40_12
XFILLER_4_165 vssd1 vccd1 vssd1 vccd1 X2_sky130_ef_sc_hd__decap_40_12
XFILLER_68_83 vccd1 vssd1 vccd1 vssd1 X2_sky130_fd_sc_hd__fill_1
XFILLER_0_393 vccd1 vssd1 vccd1 vssd1 X2_sky130_fd_sc_hd__fill_1
XFILLER_36_504 vccd1 vssd1 vccd1 vssd1 X2_sky130_fd_sc_hd__fill_1
XFILLER_36_515 vssd1 vccd1 vccd1 vssd1 X2_sky130_fd_sc_hd__fill_2
XFILLER_82_109 vssd1 vccd1 vssd1 vccd1 X2_sky130_ef_sc_hd__decap_40_12
XFILLER_75_161 vssd1 vccd1 vccd1 vssd1 X2_sky130_fd_sc_hd__fill_4
XFILLER_63_301 vssd1 vccd1 vccd1 vssd1 X2_sky130_fd_sc_hd__fill_8
XTAP_TAPCELL_ROW_59_871 vccd1 vssd1 X2_sky130_fd_sc_hd__tapvpwrvgnd_1
XFILLER_48_386 vssd1 vccd1 vccd1 vssd1 X2_sky130_fd_sc_hd__fill_2
XFILLER_63_323 vssd1 vccd1 vssd1 vccd1 X2_sky130_ef_sc_hd__decap_40_12
XFILLER_90_153 vssd1 vccd1 vssd1 vccd1 X2_sky130_ef_sc_hd__decap_40_12
XFILLER_63_389 vssd1 vccd1 vccd1 vssd1 X2_sky130_fd_sc_hd__fill_2
XFILLER_51_529 vssd1 vccd1 vssd1 vccd1 X2_sky130_ef_sc_hd__decap_40_12
XFILLER_90_197 vssd1 vccd1 vssd1 vccd1 X2_sky130_ef_sc_hd__decap_40_12
XFILLER_83_3 vssd1 vccd1 vssd1 vccd1 X2_sky130_ef_sc_hd__decap_40_12
XFILLER_98_253 vssd1 vccd1 vssd1 vccd1 X2_sky130_ef_sc_hd__decap_40_12
XFILLER_59_607 vssd1 vccd1 vccd1 vssd1 X2_sky130_fd_sc_hd__fill_4
XFILLER_58_139 vccd1 vssd1 vccd1 vssd1 X2_sky130_fd_sc_hd__fill_1
XFILLER_39_331 vssd1 vccd1 vccd1 vssd1 X2_sky130_fd_sc_hd__fill_4
XFILLER_39_386 vssd1 vccd1 vccd1 vssd1 X2_sky130_fd_sc_hd__fill_4
XFILLER_73_109 vssd1 vccd1 vccd1 vssd1 X2_sky130_fd_sc_hd__fill_2
XFILLER_27_559 vccd1 vssd1 vccd1 vssd1 X2_sky130_fd_sc_hd__fill_1
XFILLER_14_209 vssd1 vccd1 vssd1 vccd1 X2_sky130_ef_sc_hd__decap_40_12
XFILLER_54_389 vssd1 vccd1 vssd1 vccd1 X2_sky130_ef_sc_hd__decap_40_12
XFILLER_80_29 vssd1 vccd1 vssd1 vccd1 X2_sky130_ef_sc_hd__decap_40_12
XFILLER_22_253 vssd1 vccd1 vssd1 vccd1 X2_sky130_ef_sc_hd__decap_40_12
XFILLER_6_419 vccd1 vssd1 vccd1 vssd1 X2_sky130_fd_sc_hd__fill_1
XTAP_TAPCELL_ROW_20_443 vccd1 vssd1 X2_sky130_fd_sc_hd__tapvpwrvgnd_1
XFILLER_89_27 vssd1 vccd1 vssd1 vccd1 X2_sky130_ef_sc_hd__decap_40_12
XANTENNA__512__A _527_/A vssd1 vccd1 vccd1 vssd1 X2_sky130_fd_sc_hd__diode_2
XFILLER_1_113 vssd1 vccd1 vssd1 vccd1 X2_sky130_ef_sc_hd__decap_40_12
XFILLER_38_53 vssd1 vccd1 vssd1 vccd1 X2_sky130_ef_sc_hd__decap_40_12
XFILLER_38_97 vssd1 vccd1 vssd1 vccd1 X2_sky130_ef_sc_hd__decap_40_12
XFILLER_73_621 vssd1 vccd1 vccd1 vssd1 X2_sky130_fd_sc_hd__fill_4
XFILLER_64_109 vssd1 vccd1 vssd1 vccd1 X2_sky130_ef_sc_hd__decap_40_12
XFILLER_57_161 vssd1 vccd1 vccd1 vssd1 X2_sky130_fd_sc_hd__fill_4
XFILLER_45_301 vssd1 vccd1 vccd1 vssd1 X2_sky130_fd_sc_hd__fill_8
XTAP_TAPCELL_ROW_28_532 vccd1 vssd1 X2_sky130_fd_sc_hd__tapvpwrvgnd_1
XTAP_TAPCELL_ROW_56_841 vccd1 vssd1 X2_sky130_fd_sc_hd__tapvpwrvgnd_1
X_513_ vccd1 vssd1 vccd1 vssd1 _513_/Y _527_/A X2_sky130_fd_sc_hd__inv_2
XFILLER_72_153 vssd1 vccd1 vssd1 vccd1 X2_sky130_ef_sc_hd__decap_40_12
XFILLER_54_41 vssd1 vccd1 vssd1 vccd1 X2_sky130_ef_sc_hd__decap_40_12
XFILLER_26_581 vssd1 vccd1 vccd1 vssd1 X2_sky130_fd_sc_hd__fill_4
XFILLER_72_197 vssd1 vccd1 vssd1 vccd1 X2_sky130_ef_sc_hd__decap_40_12
X_444_ vssd1 vccd1 _573_/Q _609_/Q _444_/X _576_/Q hold2/X vccd1 vssd1 X2_sky130_fd_sc_hd__and4b_1
XFILLER_45_389 vssd1 vccd1 vccd1 vssd1 X2_sky130_fd_sc_hd__fill_2
XFILLER_54_85 vssd1 vccd1 vssd1 vccd1 X2_sky130_ef_sc_hd__decap_40_12
X_375_ vccd1 vssd1 vccd1 vssd1 _368_/C _375_/Y _368_/A _368_/B X2_sky130_fd_sc_hd__a21boi_1
XFILLER_9_279 vccd1 vssd1 vccd1 vssd1 X2_sky130_fd_sc_hd__fill_1
XFILLER_5_441 vssd1 vccd1 vccd1 vssd1 X2_sky130_fd_sc_hd__fill_4
XTAP_TAPCELL_ROW_93_1239 vccd1 vssd1 X2_sky130_fd_sc_hd__tapvpwrvgnd_1
XFILLER_5_485 vssd1 vccd1 vssd1 vccd1 X2_sky130_ef_sc_hd__decap_40_12
XFILLER_79_93 vssd1 vccd1 vssd1 vccd1 X2_sky130_ef_sc_hd__decap_40_12
XFILLER_95_223 vccd1 vssd1 vccd1 vssd1 X2_sky130_fd_sc_hd__fill_1
XFILLER_95_81 vssd1 vccd1 vssd1 vccd1 X2_sky130_ef_sc_hd__decap_40_12
XFILLER_83_429 vssd1 vccd1 vssd1 vccd1 X2_sky130_ef_sc_hd__decap_40_12
XFILLER_55_109 vssd1 vccd1 vccd1 vssd1 X2_sky130_fd_sc_hd__fill_2
XFILLER_36_345 vssd1 vccd1 vssd1 vccd1 X2_sky130_ef_sc_hd__decap_40_12
XFILLER_91_473 vssd1 vccd1 vssd1 vccd1 X2_sky130_ef_sc_hd__decap_40_12
XFILLER_24_529 vssd1 vccd1 vccd1 vssd1 X2_sky130_fd_sc_hd__fill_2
XFILLER_36_389 vssd1 vccd1 vccd1 vssd1 X2_sky130_fd_sc_hd__fill_8
XFILLER_51_337 vssd1 vccd1 vccd1 vssd1 X2_sky130_fd_sc_hd__fill_4
XFILLER_32_551 vssd1 vccd1 vccd1 vssd1 X2_sky130_fd_sc_hd__fill_2
XTAP_TAPCELL_ROW_62_899 vccd1 vssd1 X2_sky130_fd_sc_hd__tapvpwrvgnd_1
XFILLER_99_573 vssd1 vccd1 vssd1 vccd1 X2_sky130_ef_sc_hd__decap_40_12
XFILLER_101_501 vssd1 vccd1 vccd1 vssd1 X2_sky130_fd_sc_hd__fill_2
XFILLER_101_545 vssd1 vccd1 vssd1 vccd1 X2_sky130_ef_sc_hd__decap_40_12
XFILLER_86_245 vssd1 vccd1 vccd1 vssd1 X2_sky130_fd_sc_hd__fill_4
XFILLER_39_161 vssd1 vccd1 vccd1 vssd1 X2_sky130_fd_sc_hd__fill_4
XFILLER_101_589 vssd1 vccd1 vssd1 vccd1 X2_sky130_ef_sc_hd__decap_40_12
XFILLER_86_289 vssd1 vccd1 vssd1 vccd1 X2_sky130_ef_sc_hd__decap_40_12
XFILLER_55_610 vssd1 vccd1 vccd1 vssd1 X2_sky130_fd_sc_hd__fill_2
XFILLER_46_109 vssd1 vccd1 vssd1 vccd1 X2_sky130_ef_sc_hd__decap_40_12
XFILLER_54_153 vssd1 vccd1 vssd1 vccd1 X2_sky130_ef_sc_hd__decap_40_12
XTAP_TAPCELL_ROW_53_800 vccd1 vssd1 X2_sky130_fd_sc_hd__tapvpwrvgnd_1
XFILLER_15_529 vssd1 vccd1 vssd1 vccd1 X2_sky130_ef_sc_hd__decap_40_12
XFILLER_27_389 vssd1 vccd1 vccd1 vssd1 X2_sky130_fd_sc_hd__fill_2
XFILLER_91_39 vssd1 vccd1 vssd1 vccd1 X2_sky130_ef_sc_hd__decap_40_12
XFILLER_82_473 vssd1 vccd1 vccd1 vssd1 X2_sky130_fd_sc_hd__fill_2
XFILLER_70_624 vccd1 vssd1 vccd1 vssd1 X2_sky130_fd_sc_hd__fill_1
XFILLER_54_197 vssd1 vccd1 vccd1 vssd1 X2_sky130_fd_sc_hd__fill_8
XTAP_TAPCELL_ROW_81_1110 vccd1 vssd1 X2_sky130_fd_sc_hd__tapvpwrvgnd_1
XPHY_EDGE_ROW_59_Left_161 vccd1 vssd1 vccd1 vssd1 X2_sky130_fd_sc_hd__decap_3
XFILLER_42_359 vssd1 vccd1 vccd1 vssd1 X2_sky130_fd_sc_hd__fill_2
XFILLER_23_573 vssd1 vccd1 vssd1 vccd1 X2_sky130_ef_sc_hd__decap_40_12
XANTENNA__507__A _517_/A vssd1 vccd1 vccd1 vssd1 X2_sky130_fd_sc_hd__diode_2
XFILLER_24_77 vssd1 vccd1 vccd1 vssd1 X2_sky130_fd_sc_hd__fill_4
XFILLER_10_245 vssd1 vccd1 vccd1 vssd1 X2_sky130_fd_sc_hd__fill_4
XFILLER_6_249 vssd1 vccd1 vccd1 vssd1 X2_sky130_fd_sc_hd__fill_2
XFILLER_10_289 vssd1 vccd1 vssd1 vccd1 X2_sky130_ef_sc_hd__decap_40_12
XFILLER_40_65 vssd1 vccd1 vssd1 vccd1 X2_sky130_ef_sc_hd__decap_40_12
XTAP_TAPCELL_ROW_79_1094 vccd1 vssd1 X2_sky130_fd_sc_hd__tapvpwrvgnd_1
XPHY_EDGE_ROW_68_Left_170 vccd1 vssd1 vccd1 vssd1 X2_sky130_fd_sc_hd__decap_3
XFILLER_2_433 vssd1 vccd1 vssd1 vccd1 X2_sky130_ef_sc_hd__decap_40_12
XFILLER_2_477 vssd1 vccd1 vssd1 vccd1 X2_sky130_ef_sc_hd__decap_40_12
XFILLER_77_223 vccd1 vssd1 vccd1 vssd1 X2_sky130_fd_sc_hd__fill_1
XFILLER_1_15 vssd1 vccd1 vssd1 vccd1 X2_sky130_ef_sc_hd__decap_40_12
XTAP_TAPCELL_ROW_5_271 vccd1 vssd1 X2_sky130_fd_sc_hd__tapvpwrvgnd_1
XFILLER_18_301 vssd1 vccd1 vccd1 vssd1 X2_sky130_fd_sc_hd__fill_4
XFILLER_37_109 vssd1 vccd1 vccd1 vssd1 X2_sky130_fd_sc_hd__fill_2
XFILLER_65_429 vssd1 vccd1 vssd1 vccd1 X2_sky130_ef_sc_hd__decap_40_12
XFILLER_46_610 vssd1 vccd1 vccd1 vssd1 X2_sky130_fd_sc_hd__fill_2
XFILLER_65_51 vssd1 vccd1 vccd1 vssd1 X2_sky130_fd_sc_hd__fill_4
XFILLER_46_621 vssd1 vccd1 vccd1 vssd1 X2_sky130_fd_sc_hd__fill_4
XFILLER_18_345 vssd1 vccd1 vssd1 vccd1 X2_sky130_ef_sc_hd__decap_40_12
XFILLER_18_389 vssd1 vccd1 vssd1 vccd1 X2_sky130_ef_sc_hd__decap_40_12
XFILLER_33_337 vssd1 vccd1 vssd1 vccd1 X2_sky130_ef_sc_hd__decap_40_12
XFILLER_73_473 vssd1 vccd1 vssd1 vccd1 X2_sky130_ef_sc_hd__decap_40_12
XFILLER_61_624 vccd1 vssd1 vccd1 vssd1 X2_sky130_fd_sc_hd__fill_1
XFILLER_60_189 vssd1 vccd1 vccd1 vssd1 X2_sky130_fd_sc_hd__fill_4
X_427_ vssd1 vccd1 vssd1 vccd1 _427_/X hold5/A hold6/A hold4/X _535_/Q X2_sky130_fd_sc_hd__o211a_1
XANTENNA__541__CLK _601_/CLK vssd1 vccd1 vccd1 vssd1 X2_sky130_fd_sc_hd__diode_2
X_358_ vccd1 vssd1 vccd1 vssd1 _422_/B _422_/A hold80/X _358_/Y X2_sky130_fd_sc_hd__a21oi_1
X_289_ vssd1 vccd1 vccd1 vssd1 _590_/D hold23/X _289_/S _301_/A0 X2_sky130_fd_sc_hd__mux2_1
XFILLER_5_293 vssd1 vccd1 vssd1 vccd1 X2_sky130_ef_sc_hd__decap_40_12
XFILLER_46_3 vssd1 vccd1 vssd1 vccd1 X2_sky130_ef_sc_hd__decap_40_12
XPHY_EDGE_ROW_18_Right_18 vccd1 vssd1 vccd1 vssd1 X2_sky130_fd_sc_hd__decap_3
XFILLER_68_245 vssd1 vccd1 vccd1 vssd1 X2_sky130_fd_sc_hd__fill_4
XANTENNA__298__S _299_/S vssd1 vccd1 vccd1 vssd1 X2_sky130_fd_sc_hd__diode_2
XFILLER_28_109 vssd1 vccd1 vssd1 vccd1 X2_sky130_ef_sc_hd__decap_40_12
XFILLER_96_587 vccd1 vssd1 vccd1 vssd1 X2_sky130_fd_sc_hd__fill_1
XFILLER_68_289 vssd1 vccd1 vccd1 vssd1 X2_sky130_fd_sc_hd__fill_2
XTAP_TAPCELL_ROW_39_649 vccd1 vssd1 X2_sky130_fd_sc_hd__tapvpwrvgnd_1
XFILLER_83_237 vssd1 vccd1 vssd1 vccd1 X2_sky130_ef_sc_hd__decap_40_12
XTAP_TAPCELL_ROW_67_958 vccd1 vssd1 X2_sky130_fd_sc_hd__tapvpwrvgnd_1
Xinput3 vssd1 vccd1 _541_/D adc_data_in[11] vccd1 vssd1 X2_sky130_fd_sc_hd__buf_1
XFILLER_36_153 vssd1 vccd1 vssd1 vccd1 X2_sky130_ef_sc_hd__decap_40_12
XFILLER_91_281 vssd1 vccd1 vccd1 vssd1 X2_sky130_fd_sc_hd__fill_8
XFILLER_52_624 vccd1 vssd1 vccd1 vssd1 X2_sky130_fd_sc_hd__fill_1
XANTENNA_clkbuf_3_4__f_wb_clk_i_A clkbuf_0_wb_clk_i/X vssd1 vccd1 vccd1 vssd1 X2_sky130_fd_sc_hd__diode_2
XPHY_EDGE_ROW_27_Right_27 vccd1 vssd1 vccd1 vssd1 X2_sky130_fd_sc_hd__decap_3
XFILLER_36_197 vssd1 vccd1 vssd1 vccd1 X2_sky130_ef_sc_hd__decap_40_12
XFILLER_101_27 vccd1 vssd1 vccd1 vssd1 X2_sky130_fd_sc_hd__fill_1
XFILLER_51_167 vccd1 vssd1 vccd1 vssd1 X2_sky130_fd_sc_hd__fill_1
XFILLER_20_587 vccd1 vssd1 vccd1 vssd1 X2_sky130_fd_sc_hd__fill_1
XPHY_EDGE_ROW_36_Right_36 vccd1 vssd1 vccd1 vssd1 X2_sky130_fd_sc_hd__decap_3
XFILLER_101_331 vccd1 vssd1 vccd1 vssd1 X2_sky130_fd_sc_hd__fill_1
XFILLER_59_223 vccd1 vssd1 vccd1 vssd1 X2_sky130_fd_sc_hd__fill_1
XFILLER_19_55 vccd1 vssd1 vccd1 vssd1 X2_sky130_fd_sc_hd__fill_1
XFILLER_19_109 vssd1 vccd1 vccd1 vssd1 X2_sky130_fd_sc_hd__fill_2
XTAP_TAPCELL_ROW_2_241 vccd1 vssd1 X2_sky130_fd_sc_hd__tapvpwrvgnd_1
XFILLER_70_421 vssd1 vccd1 vssd1 vccd1 X2_sky130_ef_sc_hd__decap_40_12
XFILLER_55_473 vssd1 vccd1 vssd1 vccd1 X2_sky130_ef_sc_hd__decap_40_12
XPHY_EDGE_ROW_45_Right_45 vccd1 vssd1 vccd1 vssd1 X2_sky130_fd_sc_hd__decap_3
XFILLER_43_624 vccd1 vssd1 vccd1 vssd1 X2_sky130_fd_sc_hd__fill_1
XFILLER_15_337 vssd1 vccd1 vssd1 vccd1 X2_sky130_ef_sc_hd__decap_40_12
XFILLER_30_307 vccd1 vssd1 vccd1 vssd1 X2_sky130_fd_sc_hd__fill_1
XFILLER_42_189 vssd1 vccd1 vccd1 vssd1 X2_sky130_fd_sc_hd__fill_4
XFILLER_7_503 vccd1 vssd1 vccd1 vssd1 X2_sky130_fd_sc_hd__fill_1
XPHY_EDGE_ROW_54_Right_54 vccd1 vssd1 vccd1 vssd1 X2_sky130_fd_sc_hd__decap_3
XTAP_TAPCELL_ROW_90_1209 vccd1 vssd1 X2_sky130_fd_sc_hd__tapvpwrvgnd_1
XFILLER_78_587 vccd1 vssd1 vccd1 vssd1 X2_sky130_fd_sc_hd__fill_1
XFILLER_76_83 vccd1 vssd1 vccd1 vssd1 X2_sky130_fd_sc_hd__fill_1
XFILLER_65_237 vssd1 vccd1 vssd1 vccd1 X2_sky130_ef_sc_hd__decap_40_12
XFILLER_93_557 vssd1 vccd1 vccd1 vssd1 X2_sky130_fd_sc_hd__fill_2
XPHY_EDGE_ROW_63_Right_63 vccd1 vssd1 vccd1 vssd1 X2_sky130_fd_sc_hd__decap_3
XFILLER_18_153 vssd1 vccd1 vssd1 vccd1 X2_sky130_ef_sc_hd__decap_40_12
XFILLER_34_624 vccd1 vssd1 vccd1 vssd1 X2_sky130_fd_sc_hd__fill_1
XTAP_TAPCELL_ROW_36_619 vccd1 vssd1 X2_sky130_fd_sc_hd__tapvpwrvgnd_1
XTAP_TAPCELL_ROW_64_928 vccd1 vssd1 X2_sky130_fd_sc_hd__tapvpwrvgnd_1
XFILLER_46_473 vssd1 vccd1 vccd1 vssd1 X2_sky130_fd_sc_hd__fill_2
XFILLER_18_197 vssd1 vccd1 vssd1 vccd1 X2_sky130_ef_sc_hd__decap_40_12
XFILLER_73_281 vssd1 vccd1 vssd1 vccd1 X2_sky130_ef_sc_hd__decap_40_12
XFILLER_33_167 vccd1 vssd1 vccd1 vssd1 X2_sky130_fd_sc_hd__fill_1
XTAP_TAPCELL_ROW_16_398 vccd1 vssd1 X2_sky130_fd_sc_hd__tapvpwrvgnd_1
XFILLER_21_329 vssd1 vccd1 vccd1 vssd1 X2_sky130_fd_sc_hd__fill_4
XPHY_EDGE_ROW_72_Right_72 vccd1 vssd1 vccd1 vssd1 X2_sky130_fd_sc_hd__decap_3
XFILLER_88_307 vccd1 vssd1 vccd1 vssd1 X2_sky130_fd_sc_hd__fill_1
XANTENNA__313__C _317_/C vssd1 vccd1 vccd1 vssd1 X2_sky130_fd_sc_hd__diode_2
XFILLER_84_513 vssd1 vccd1 vssd1 vccd1 X2_sky130_ef_sc_hd__decap_40_12
XFILLER_69_587 vssd1 vccd1 vccd1 vssd1 X2_sky130_fd_sc_hd__fill_2
XFILLER_69_565 vssd1 vccd1 vccd1 vssd1 X2_sky130_fd_sc_hd__fill_2
XFILLER_29_429 vssd1 vccd1 vssd1 vccd1 X2_sky130_ef_sc_hd__decap_40_12
XPHY_EDGE_ROW_81_Right_81 vccd1 vssd1 vccd1 vssd1 X2_sky130_fd_sc_hd__decap_3
XFILLER_69_598 vssd1 vccd1 vccd1 vssd1 X2_sky130_fd_sc_hd__fill_2
XFILLER_84_557 vssd1 vccd1 vssd1 vccd1 X2_sky130_ef_sc_hd__decap_40_12
XFILLER_25_613 vssd1 vccd1 vccd1 vssd1 X2_sky130_fd_sc_hd__fill_2
XFILLER_37_462 vssd1 vccd1 vccd1 vssd1 X2_sky130_fd_sc_hd__fill_4
XFILLER_37_484 vssd1 vccd1 vccd1 vssd1 X2_sky130_fd_sc_hd__fill_2
XFILLER_52_421 vssd1 vccd1 vccd1 vssd1 X2_sky130_fd_sc_hd__fill_2
XFILLER_12_307 vccd1 vssd1 vccd1 vssd1 X2_sky130_fd_sc_hd__fill_1
XFILLER_52_465 vssd1 vccd1 vccd1 vssd1 X2_sky130_fd_sc_hd__fill_4
XFILLER_24_189 vssd1 vccd1 vccd1 vssd1 X2_sky130_fd_sc_hd__fill_4
XFILLER_52_498 vssd1 vccd1 vccd1 vssd1 X2_sky130_fd_sc_hd__fill_2
XPHY_EDGE_ROW_90_Right_90 vccd1 vssd1 vccd1 vssd1 X2_sky130_fd_sc_hd__decap_3
XFILLER_97_27 vssd1 vccd1 vssd1 vccd1 X2_sky130_ef_sc_hd__decap_40_12
XTAP_TAPCELL_ROW_76_1053 vccd1 vssd1 X2_sky130_fd_sc_hd__tapvpwrvgnd_1
XTAP_TAPCELL_ROW_7_300 vccd1 vssd1 X2_sky130_fd_sc_hd__tapvpwrvgnd_1
XFILLER_79_329 vssd1 vccd1 vccd1 vssd1 X2_sky130_fd_sc_hd__fill_4
XANTENNA__520__A _521_/A vssd1 vccd1 vccd1 vssd1 X2_sky130_fd_sc_hd__diode_2
XFILLER_87_340 vssd1 vccd1 vssd1 vccd1 X2_sky130_ef_sc_hd__decap_40_12
XFILLER_47_215 vssd1 vccd1 vccd1 vssd1 X2_sky130_fd_sc_hd__fill_2
XFILLER_75_557 vssd1 vccd1 vccd1 vssd1 X2_sky130_fd_sc_hd__fill_2
XFILLER_16_613 vssd1 vccd1 vssd1 vccd1 X2_sky130_ef_sc_hd__decap_40_12
XFILLER_28_473 vssd1 vccd1 vccd1 vssd1 X2_sky130_fd_sc_hd__fill_2
XFILLER_46_53 vssd1 vccd1 vssd1 vccd1 X2_sky130_ef_sc_hd__decap_40_12
XTAP_TAPCELL_ROW_87_1182 vccd1 vssd1 X2_sky130_fd_sc_hd__tapvpwrvgnd_1
XFILLER_55_281 vssd1 vccd1 vccd1 vssd1 X2_sky130_fd_sc_hd__fill_4
XFILLER_46_97 vssd1 vccd1 vssd1 vccd1 X2_sky130_ef_sc_hd__decap_40_12
XFILLER_43_421 vssd1 vccd1 vccd1 vssd1 X2_sky130_fd_sc_hd__fill_4
XFILLER_15_167 vccd1 vssd1 vccd1 vssd1 X2_sky130_fd_sc_hd__fill_1
XFILLER_31_605 vssd1 vccd1 vccd1 vssd1 X2_sky130_fd_sc_hd__fill_8
XFILLER_70_251 vccd1 vssd1 vccd1 vssd1 X2_sky130_fd_sc_hd__fill_1
XFILLER_43_487 vssd1 vccd1 vccd1 vssd1 X2_sky130_fd_sc_hd__fill_8
XFILLER_30_137 vssd1 vccd1 vccd1 vssd1 X2_sky130_fd_sc_hd__fill_2
XFILLER_62_41 vssd1 vccd1 vssd1 vccd1 X2_sky130_ef_sc_hd__decap_40_12
XFILLER_43_498 vssd1 vccd1 vccd1 vssd1 X2_sky130_fd_sc_hd__fill_2
XTAP_TAPCELL_ROW_41_666 vccd1 vssd1 X2_sky130_fd_sc_hd__tapvpwrvgnd_1
XANTENNA_clkbuf_3_3__f_wb_clk_i_X _599_/CLK vssd1 vccd1 vccd1 vssd1 X2_sky130_fd_sc_hd__diode_2
XFILLER_62_85 vssd1 vccd1 vssd1 vccd1 X2_sky130_ef_sc_hd__decap_40_12
XFILLER_7_333 vssd1 vccd1 vccd1 vssd1 X2_sky130_fd_sc_hd__fill_2
XFILLER_11_373 vssd1 vccd1 vssd1 vccd1 X2_sky130_ef_sc_hd__decap_40_12
XTAP_TAPCELL_ROW_13_368 vccd1 vssd1 X2_sky130_fd_sc_hd__tapvpwrvgnd_1
XFILLER_7_69 vssd1 vccd1 vssd1 vccd1 X2_sky130_ef_sc_hd__decap_40_12
XFILLER_3_561 vssd1 vccd1 vssd1 vccd1 X2_sky130_ef_sc_hd__decap_40_12
XFILLER_97_137 vssd1 vccd1 vssd1 vccd1 X2_sky130_ef_sc_hd__decap_40_12
XFILLER_87_93 vssd1 vccd1 vssd1 vccd1 X2_sky130_ef_sc_hd__decap_40_12
XFILLER_66_513 vssd1 vccd1 vssd1 vccd1 X2_sky130_ef_sc_hd__decap_40_12
XFILLER_93_332 vssd1 vccd1 vccd1 vssd1 X2_sky130_fd_sc_hd__fill_4
XFILLER_81_505 vssd1 vccd1 vssd1 vccd1 X2_sky130_ef_sc_hd__decap_40_12
XFILLER_66_557 vssd1 vccd1 vssd1 vccd1 X2_sky130_ef_sc_hd__decap_40_12
XTAP_TAPCELL_ROW_49_755 vccd1 vssd1 X2_sky130_fd_sc_hd__tapvpwrvgnd_1
XFILLER_19_473 vssd1 vccd1 vssd1 vccd1 X2_sky130_ef_sc_hd__decap_40_12
XFILLER_93_376 vssd1 vccd1 vssd1 vccd1 X2_sky130_ef_sc_hd__decap_40_12
XFILLER_34_421 vssd1 vccd1 vccd1 vssd1 X2_sky130_fd_sc_hd__fill_4
XFILLER_61_262 vssd1 vccd1 vssd1 vccd1 X2_sky130_ef_sc_hd__decap_40_12
XFILLER_21_137 vssd1 vccd1 vssd1 vccd1 X2_sky130_ef_sc_hd__decap_40_12
XFILLER_88_137 vssd1 vccd1 vccd1 vssd1 X2_sky130_fd_sc_hd__fill_2
XFILLER_69_373 vssd1 vccd1 vssd1 vccd1 X2_sky130_ef_sc_hd__decap_40_12
XFILLER_29_237 vssd1 vccd1 vssd1 vccd1 X2_sky130_ef_sc_hd__decap_40_12
XFILLER_57_557 vssd1 vccd1 vccd1 vssd1 X2_sky130_fd_sc_hd__fill_2
XFILLER_84_365 vssd1 vccd1 vssd1 vccd1 X2_sky130_ef_sc_hd__decap_40_12
XFILLER_37_281 vssd1 vccd1 vccd1 vssd1 X2_sky130_fd_sc_hd__fill_2
XPHY_EDGE_ROW_0_Right_0 vccd1 vssd1 vccd1 vssd1 X2_sky130_fd_sc_hd__decap_3
XFILLER_52_273 vssd1 vccd1 vccd1 vssd1 X2_sky130_fd_sc_hd__fill_2
XFILLER_9_609 vssd1 vccd1 vccd1 vssd1 X2_sky130_fd_sc_hd__fill_4
XFILLER_12_137 vssd1 vccd1 vccd1 vssd1 X2_sky130_fd_sc_hd__fill_2
XFILLER_40_457 vssd1 vccd1 vssd1 vccd1 X2_sky130_ef_sc_hd__decap_40_12
XANTENNA__515__A _517_/A vssd1 vccd1 vccd1 vssd1 X2_sky130_fd_sc_hd__diode_2
XANTENNA__602__CLK _607_/CLK vssd1 vccd1 vccd1 vssd1 X2_sky130_fd_sc_hd__diode_2
XTAP_TAPCELL_ROW_10_327 vccd1 vssd1 X2_sky130_fd_sc_hd__tapvpwrvgnd_1
XFILLER_32_77 vssd1 vccd1 vccd1 vssd1 X2_sky130_fd_sc_hd__fill_4
XFILLER_79_137 vssd1 vccd1 vssd1 vccd1 X2_sky130_ef_sc_hd__decap_40_12
XANTENNA_input33_A wbs_dat_i[4] vssd1 vccd1 vccd1 vssd1 X2_sky130_fd_sc_hd__diode_2
XFILLER_87_181 vssd1 vccd1 vssd1 vccd1 X2_sky130_ef_sc_hd__decap_40_12
XTAP_TAPCELL_ROW_89_1200 vccd1 vssd1 X2_sky130_fd_sc_hd__tapvpwrvgnd_1
XFILLER_48_524 vssd1 vccd1 vccd1 vssd1 X2_sky130_fd_sc_hd__fill_8
XFILLER_48_546 vssd1 vccd1 vccd1 vssd1 X2_sky130_fd_sc_hd__fill_2
XTAP_TAPCELL_ROW_18_416 vccd1 vssd1 X2_sky130_fd_sc_hd__tapvpwrvgnd_1
XFILLER_63_505 vssd1 vccd1 vssd1 vccd1 X2_sky130_ef_sc_hd__decap_40_12
XTAP_TAPCELL_ROW_46_725 vccd1 vssd1 X2_sky130_fd_sc_hd__tapvpwrvgnd_1
XFILLER_16_421 vssd1 vccd1 vssd1 vccd1 X2_sky130_ef_sc_hd__decap_40_12
XFILLER_73_51 vssd1 vccd1 vccd1 vssd1 X2_sky130_fd_sc_hd__fill_4
XFILLER_43_273 vssd1 vccd1 vccd1 vssd1 X2_sky130_fd_sc_hd__fill_4
XFILLER_11_181 vssd1 vccd1 vssd1 vccd1 X2_sky130_ef_sc_hd__decap_40_12
XFILLER_98_81 vssd1 vccd1 vccd1 vssd1 X2_sky130_fd_sc_hd__fill_2
XFILLER_3_391 vccd1 vssd1 vccd1 vssd1 X2_sky130_fd_sc_hd__fill_1
XPHY_EDGE_ROW_13_Left_115 vccd1 vssd1 vccd1 vssd1 X2_sky130_fd_sc_hd__decap_3
XFILLER_66_321 vssd1 vccd1 vssd1 vccd1 X2_sky130_ef_sc_hd__decap_40_12
XFILLER_39_557 vssd1 vccd1 vccd1 vssd1 X2_sky130_fd_sc_hd__fill_2
XFILLER_66_365 vssd1 vccd1 vssd1 vccd1 X2_sky130_ef_sc_hd__decap_40_12
XFILLER_19_281 vssd1 vccd1 vssd1 vccd1 X2_sky130_ef_sc_hd__decap_40_12
XFILLER_81_335 vccd1 vssd1 vccd1 vssd1 X2_sky130_fd_sc_hd__fill_1
XFILLER_34_251 vccd1 vssd1 vccd1 vssd1 X2_sky130_fd_sc_hd__fill_1
XPHY_EDGE_ROW_22_Left_124 vccd1 vssd1 vccd1 vssd1 X2_sky130_fd_sc_hd__decap_3
XFILLER_22_413 vssd1 vccd1 vccd1 vssd1 X2_sky130_fd_sc_hd__fill_4
XFILLER_34_273 vssd1 vccd1 vccd1 vssd1 X2_sky130_fd_sc_hd__fill_2
XFILLER_22_457 vssd1 vccd1 vssd1 vccd1 X2_sky130_ef_sc_hd__decap_40_12
XPHY_EDGE_ROW_31_Left_133 vccd1 vssd1 vccd1 vssd1 X2_sky130_fd_sc_hd__decap_3
XFILLER_78_29 vssd1 vccd1 vssd1 vccd1 X2_sky130_ef_sc_hd__decap_40_12
XTAP_TAPCELL_ROW_73_1023 vccd1 vssd1 X2_sky130_fd_sc_hd__tapvpwrvgnd_1
XFILLER_1_317 vssd1 vccd1 vccd1 vssd1 X2_sky130_fd_sc_hd__fill_4
XFILLER_69_181 vssd1 vccd1 vssd1 vccd1 X2_sky130_ef_sc_hd__decap_40_12
XFILLER_45_505 vssd1 vccd1 vccd1 vssd1 X2_sky130_fd_sc_hd__fill_4
XFILLER_27_55 vccd1 vssd1 vccd1 vssd1 X2_sky130_fd_sc_hd__fill_1
XFILLER_84_195 vccd1 vssd1 vccd1 vssd1 X2_sky130_fd_sc_hd__fill_1
XFILLER_45_549 vccd1 vssd1 vccd1 vssd1 X2_sky130_fd_sc_hd__fill_1
XPHY_EDGE_ROW_40_Left_142 vccd1 vssd1 vccd1 vssd1 X2_sky130_fd_sc_hd__decap_3
XTAP_TAPCELL_ROW_84_1141 vccd1 vssd1 X2_sky130_fd_sc_hd__tapvpwrvgnd_1
XFILLER_72_357 vssd1 vccd1 vccd1 vssd1 X2_sky130_fd_sc_hd__fill_4
X_460_ vccd1 vssd1 vccd1 vssd1 _460_/Y _473_/A X2_sky130_fd_sc_hd__inv_2
XFILLER_25_273 vssd1 vccd1 vccd1 vssd1 X2_sky130_fd_sc_hd__fill_4
XFILLER_53_571 vssd1 vccd1 vccd1 vssd1 X2_sky130_fd_sc_hd__fill_4
X_391_ vssd1 vccd1 vssd1 vccd1 _392_/C _393_/C _413_/A _359_/Y _360_/X X2_sky130_fd_sc_hd__a211o_1
XFILLER_9_417 vssd1 vccd1 vssd1 vccd1 X2_sky130_ef_sc_hd__decap_40_12
XTAP_TAPCELL_ROW_23_474 vccd1 vssd1 X2_sky130_fd_sc_hd__tapvpwrvgnd_1
XFILLER_40_265 vssd1 vccd1 vssd1 vccd1 X2_sky130_ef_sc_hd__decap_40_12
XTAP_TAPCELL_ROW_51_783 vccd1 vssd1 X2_sky130_fd_sc_hd__tapvpwrvgnd_1
XFILLER_4_133 vssd1 vccd1 vccd1 vssd1 X2_sky130_fd_sc_hd__fill_4
XFILLER_4_15 vssd1 vccd1 vssd1 vccd1 X2_sky130_ef_sc_hd__decap_40_12
XTAP_TAPCELL_ROW_95_1270 vccd1 vssd1 X2_sky130_fd_sc_hd__tapvpwrvgnd_1
XFILLER_4_177 vssd1 vccd1 vssd1 vccd1 X2_sky130_ef_sc_hd__decap_40_12
XFILLER_95_405 vssd1 vccd1 vssd1 vccd1 X2_sky130_ef_sc_hd__decap_40_12
XFILLER_95_449 vssd1 vccd1 vssd1 vccd1 X2_sky130_ef_sc_hd__decap_40_12
XFILLER_48_321 vssd1 vccd1 vssd1 vccd1 X2_sky130_ef_sc_hd__decap_40_12
XTAP_TAPCELL_ROW_59_872 vccd1 vssd1 X2_sky130_fd_sc_hd__tapvpwrvgnd_1
XFILLER_48_365 vccd1 vssd1 vccd1 vssd1 X2_sky130_fd_sc_hd__fill_1
XFILLER_36_549 vssd1 vccd1 vccd1 vssd1 X2_sky130_fd_sc_hd__fill_2
XFILLER_90_121 vssd1 vccd1 vssd1 vccd1 X2_sky130_ef_sc_hd__decap_40_12
XFILLER_84_83 vccd1 vssd1 vccd1 vssd1 X2_sky130_fd_sc_hd__fill_1
XFILLER_63_335 vccd1 vssd1 vccd1 vssd1 X2_sky130_fd_sc_hd__fill_1
XFILLER_16_251 vccd1 vssd1 vccd1 vssd1 X2_sky130_fd_sc_hd__fill_1
XFILLER_90_165 vssd1 vccd1 vssd1 vccd1 X2_sky130_ef_sc_hd__decap_40_12
X_589_ vssd1 vccd1 vccd1 vssd1 _606_/CLK _589_/D _509_/Y _589_/Q X2_sky130_fd_sc_hd__dfrtp_1
XFILLER_31_221 vssd1 vccd1 vccd1 vssd1 X2_sky130_fd_sc_hd__fill_2
XFILLER_76_3 vssd1 vccd1 vssd1 vccd1 X2_sky130_ef_sc_hd__decap_40_12
XFILLER_98_221 vssd1 vccd1 vssd1 vccd1 X2_sky130_ef_sc_hd__decap_40_12
XFILLER_98_265 vssd1 vccd1 vssd1 vccd1 X2_sky130_ef_sc_hd__decap_40_12
XFILLER_27_505 vssd1 vccd1 vssd1 vccd1 X2_sky130_ef_sc_hd__decap_40_12
XFILLER_66_195 vccd1 vssd1 vccd1 vssd1 X2_sky130_fd_sc_hd__fill_1
XFILLER_81_165 vssd1 vccd1 vccd1 vssd1 X2_sky130_fd_sc_hd__fill_2
XFILLER_22_221 vssd1 vccd1 vssd1 vccd1 X2_sky130_ef_sc_hd__decap_40_12
XFILLER_50_530 vssd1 vccd1 vccd1 vssd1 X2_sky130_fd_sc_hd__fill_2
XFILLER_22_265 vssd1 vccd1 vssd1 vccd1 X2_sky130_ef_sc_hd__decap_40_12
XFILLER_13_57 vssd1 vccd1 vssd1 vccd1 X2_sky130_ef_sc_hd__decap_40_12
XTAP_TAPCELL_ROW_20_444 vccd1 vssd1 X2_sky130_fd_sc_hd__tapvpwrvgnd_1
XFILLER_89_39 vssd1 vccd1 vssd1 vccd1 X2_sky130_ef_sc_hd__decap_40_12
XFILLER_1_125 vssd1 vccd1 vssd1 vccd1 X2_sky130_ef_sc_hd__decap_40_12
XFILLER_89_221 vssd1 vccd1 vccd1 vssd1 X2_sky130_fd_sc_hd__fill_2
XFILLER_77_405 vssd1 vccd1 vssd1 vccd1 X2_sky130_ef_sc_hd__decap_40_12
XFILLER_1_169 vssd1 vccd1 vssd1 vccd1 X2_sky130_ef_sc_hd__decap_40_12
XFILLER_77_449 vssd1 vccd1 vssd1 vccd1 X2_sky130_ef_sc_hd__decap_40_12
XFILLER_38_65 vssd1 vccd1 vssd1 vccd1 X2_sky130_ef_sc_hd__decap_40_12
XFILLER_92_419 vccd1 vssd1 vccd1 vssd1 X2_sky130_fd_sc_hd__fill_1
XTAP_TAPCELL_ROW_28_533 vccd1 vssd1 X2_sky130_fd_sc_hd__tapvpwrvgnd_1
XFILLER_72_121 vssd1 vccd1 vssd1 vccd1 X2_sky130_ef_sc_hd__decap_40_12
XTAP_TAPCELL_ROW_56_831 vccd1 vssd1 X2_sky130_fd_sc_hd__tapvpwrvgnd_1
XFILLER_45_324 vssd1 vccd1 vccd1 vssd1 X2_sky130_fd_sc_hd__fill_2
X_512_ vccd1 vssd1 vccd1 vssd1 _512_/Y _527_/A X2_sky130_fd_sc_hd__inv_2
XFILLER_72_165 vssd1 vccd1 vssd1 vccd1 X2_sky130_ef_sc_hd__decap_40_12
XFILLER_60_305 vssd1 vccd1 vccd1 vssd1 X2_sky130_fd_sc_hd__fill_2
XFILLER_54_53 vssd1 vccd1 vssd1 vccd1 X2_sky130_ef_sc_hd__decap_40_12
X_443_ vssd1 vccd1 vccd1 vssd1 _443_/X _298_/A0 _440_/Y hold49/X _442_/X X2_sky130_fd_sc_hd__o2bb2a_1
XFILLER_13_221 vssd1 vccd1 vccd1 vssd1 X2_sky130_fd_sc_hd__fill_2
XFILLER_54_97 vssd1 vccd1 vssd1 vccd1 X2_sky130_ef_sc_hd__decap_40_12
XFILLER_53_390 vssd1 vccd1 vccd1 vssd1 X2_sky130_fd_sc_hd__fill_2
XFILLER_9_225 vssd1 vccd1 vssd1 vccd1 X2_sky130_ef_sc_hd__decap_40_12
X_374_ vccd1 vssd1 vccd1 vssd1 _373_/C _373_/B _371_/X _374_/X X2_sky130_fd_sc_hd__a21o_1
XFILLER_70_41 vssd1 vccd1 vssd1 vccd1 X2_sky130_ef_sc_hd__decap_40_12
XFILLER_70_85 vssd1 vccd1 vssd1 vccd1 X2_sky130_ef_sc_hd__decap_40_12
XFILLER_5_497 vssd1 vccd1 vccd1 vssd1 X2_sky130_fd_sc_hd__fill_4
XANTENNA__312__B1 _304_/X vssd1 vccd1 vccd1 vssd1 X2_sky130_fd_sc_hd__diode_2
XFILLER_0_191 vccd1 vssd1 vccd1 vssd1 X2_sky130_fd_sc_hd__fill_1
XFILLER_95_93 vssd1 vccd1 vssd1 vccd1 X2_sky130_ef_sc_hd__decap_40_12
XFILLER_95_279 vccd1 vssd1 vccd1 vssd1 X2_sky130_fd_sc_hd__fill_1
XFILLER_48_195 vccd1 vssd1 vccd1 vssd1 X2_sky130_fd_sc_hd__fill_1
XFILLER_36_357 vssd1 vccd1 vccd1 vssd1 X2_sky130_fd_sc_hd__fill_4
XFILLER_91_441 vssd1 vccd1 vccd1 vssd1 X2_sky130_fd_sc_hd__fill_4
XFILLER_91_485 vssd1 vccd1 vssd1 vccd1 X2_sky130_ef_sc_hd__decap_40_12
XFILLER_63_165 vssd1 vccd1 vccd1 vssd1 X2_sky130_fd_sc_hd__fill_2
XFILLER_51_327 vssd1 vccd1 vccd1 vssd1 X2_sky130_fd_sc_hd__fill_2
XFILLER_51_305 vssd1 vccd1 vccd1 vssd1 X2_sky130_fd_sc_hd__fill_8
XFILLER_51_349 vssd1 vccd1 vssd1 vccd1 X2_sky130_ef_sc_hd__decap_40_12
XFILLER_32_596 vssd1 vccd1 vssd1 vccd1 X2_sky130_ef_sc_hd__decap_40_12
XFILLER_99_541 vssd1 vccd1 vssd1 vccd1 X2_sky130_ef_sc_hd__decap_40_12
XFILLER_99_585 vssd1 vccd1 vssd1 vccd1 X2_sky130_ef_sc_hd__decap_40_12
XFILLER_59_405 vssd1 vccd1 vssd1 vccd1 X2_sky130_ef_sc_hd__decap_40_12
XFILLER_101_557 vssd1 vccd1 vccd1 vssd1 X2_sky130_fd_sc_hd__fill_2
XFILLER_59_449 vssd1 vccd1 vssd1 vccd1 X2_sky130_ef_sc_hd__decap_40_12
XFILLER_74_419 vccd1 vssd1 vccd1 vssd1 X2_sky130_fd_sc_hd__fill_1
XFILLER_27_335 vccd1 vssd1 vccd1 vssd1 X2_sky130_fd_sc_hd__fill_1
XFILLER_54_121 vssd1 vccd1 vssd1 vccd1 X2_sky130_ef_sc_hd__decap_40_12
XFILLER_54_165 vssd1 vccd1 vssd1 vccd1 X2_sky130_ef_sc_hd__decap_40_12
XTAP_TAPCELL_ROW_53_801 vccd1 vssd1 X2_sky130_fd_sc_hd__tapvpwrvgnd_1
XFILLER_42_327 vssd1 vccd1 vssd1 vccd1 X2_sky130_ef_sc_hd__decap_40_12
XFILLER_42_305 vssd1 vccd1 vccd1 vssd1 X2_sky130_fd_sc_hd__fill_2
XFILLER_23_541 vssd1 vccd1 vssd1 vccd1 X2_sky130_ef_sc_hd__decap_40_12
XTAP_TAPCELL_ROW_81_1111 vccd1 vssd1 X2_sky130_fd_sc_hd__tapvpwrvgnd_1
XFILLER_23_585 vssd1 vccd1 vssd1 vccd1 X2_sky130_ef_sc_hd__decap_40_12
XTAP_TAPCELL_ROW_33_580 vccd1 vssd1 X2_sky130_fd_sc_hd__tapvpwrvgnd_1
XFILLER_50_393 vssd1 vccd1 vccd1 vssd1 X2_sky130_fd_sc_hd__fill_2
XANTENNA__523__A _525_/A vssd1 vccd1 vccd1 vssd1 X2_sky130_fd_sc_hd__diode_2
XFILLER_40_77 vssd1 vccd1 vccd1 vssd1 X2_sky130_fd_sc_hd__fill_4
XTAP_TAPCELL_ROW_79_1084 vccd1 vssd1 X2_sky130_fd_sc_hd__tapvpwrvgnd_1
XFILLER_2_401 vssd1 vccd1 vssd1 vccd1 X2_sky130_ef_sc_hd__decap_40_12
XFILLER_2_445 vssd1 vccd1 vssd1 vccd1 X2_sky130_ef_sc_hd__decap_40_12
XFILLER_6_3 vssd1 vccd1 vssd1 vccd1 X2_sky130_ef_sc_hd__decap_40_12
XFILLER_2_489 vssd1 vccd1 vssd1 vccd1 X2_sky130_ef_sc_hd__decap_40_12
XFILLER_1_27 vssd1 vccd1 vssd1 vccd1 X2_sky130_ef_sc_hd__decap_40_12
XTAP_TAPCELL_ROW_5_272 vccd1 vssd1 X2_sky130_fd_sc_hd__tapvpwrvgnd_1
XFILLER_77_279 vccd1 vssd1 vccd1 vssd1 X2_sky130_fd_sc_hd__fill_1
XFILLER_92_249 vssd1 vccd1 vccd1 vssd1 X2_sky130_fd_sc_hd__fill_2
XFILLER_18_357 vssd1 vccd1 vccd1 vssd1 X2_sky130_fd_sc_hd__fill_4
XFILLER_73_441 vssd1 vccd1 vccd1 vssd1 X2_sky130_fd_sc_hd__fill_4
XFILLER_73_485 vssd1 vccd1 vssd1 vccd1 X2_sky130_ef_sc_hd__decap_40_12
XFILLER_61_614 vssd1 vccd1 vccd1 vssd1 X2_sky130_fd_sc_hd__fill_2
XFILLER_45_165 vssd1 vccd1 vccd1 vssd1 X2_sky130_fd_sc_hd__fill_2
XFILLER_33_349 vssd1 vccd1 vccd1 vssd1 X2_sky130_fd_sc_hd__fill_4
XFILLER_81_51 vssd1 vccd1 vccd1 vssd1 X2_sky130_fd_sc_hd__fill_4
X_426_ vccd1 vssd1 vssd1 vccd1 _425_/X _426_/B _426_/Y X2_sky130_fd_sc_hd__nand2b_1
XFILLER_14_585 vssd1 vccd1 vccd1 vssd1 X2_sky130_fd_sc_hd__fill_2
X_357_ vccd1 vssd1 vccd1 vssd1 _425_/D _261_/Y _348_/B _357_/X _355_/X X2_sky130_fd_sc_hd__a22o_1
XFILLER_41_393 vssd1 vccd1 vssd1 vccd1 X2_sky130_ef_sc_hd__decap_40_12
X_288_ vssd1 vccd1 vccd1 vssd1 _591_/D hold40/X _289_/S _298_/A0 X2_sky130_fd_sc_hd__mux2_1
XFILLER_5_261 vssd1 vccd1 vssd1 vccd1 X2_sky130_ef_sc_hd__decap_40_12
XFILLER_39_3 vccd1 vssd1 vccd1 vssd1 X2_sky130_fd_sc_hd__fill_1
XFILLER_96_533 vssd1 vccd1 vssd1 vccd1 X2_sky130_ef_sc_hd__decap_40_12
XFILLER_83_205 vssd1 vccd1 vssd1 vccd1 X2_sky130_ef_sc_hd__decap_40_12
XFILLER_56_419 vccd1 vssd1 vccd1 vssd1 X2_sky130_fd_sc_hd__fill_1
Xinput4 vssd1 vccd1 _531_/D adc_data_in[1] vccd1 vssd1 X2_sky130_fd_sc_hd__buf_1
XFILLER_83_249 vssd1 vccd1 vssd1 vccd1 X2_sky130_ef_sc_hd__decap_40_12
XTAP_TAPCELL_ROW_67_959 vccd1 vssd1 X2_sky130_fd_sc_hd__tapvpwrvgnd_1
XFILLER_36_121 vssd1 vccd1 vssd1 vccd1 X2_sky130_ef_sc_hd__decap_40_12
XFILLER_24_305 vssd1 vccd1 vccd1 vssd1 X2_sky130_fd_sc_hd__fill_2
XFILLER_36_165 vssd1 vccd1 vssd1 vccd1 X2_sky130_ef_sc_hd__decap_40_12
XFILLER_51_113 vssd1 vccd1 vssd1 vccd1 X2_sky130_ef_sc_hd__decap_40_12
XFILLER_20_533 vssd1 vccd1 vssd1 vccd1 X2_sky130_ef_sc_hd__decap_40_12
XTAP_TAPCELL_ROW_30_550 vccd1 vssd1 X2_sky130_fd_sc_hd__tapvpwrvgnd_1
XPHY_EDGE_ROW_5_Left_107 vccd1 vssd1 vccd1 vssd1 X2_sky130_fd_sc_hd__decap_3
XFILLER_86_29 vssd1 vccd1 vssd1 vccd1 X2_sky130_ef_sc_hd__decap_40_12
XFILLER_101_321 vssd1 vccd1 vccd1 vssd1 X2_sky130_fd_sc_hd__fill_4
XFILLER_99_393 vssd1 vccd1 vccd1 vssd1 X2_sky130_fd_sc_hd__fill_8
XFILLER_99_382 vssd1 vccd1 vccd1 vssd1 X2_sky130_fd_sc_hd__fill_8
XFILLER_101_343 vssd1 vccd1 vccd1 vssd1 X2_sky130_fd_sc_hd__fill_2
XFILLER_101_365 vssd1 vccd1 vccd1 vssd1 X2_sky130_fd_sc_hd__fill_4
XFILLER_59_279 vccd1 vssd1 vccd1 vssd1 X2_sky130_fd_sc_hd__fill_1
XFILLER_47_408 vssd1 vccd1 vccd1 vssd1 X2_sky130_fd_sc_hd__fill_4
XTAP_TAPCELL_ROW_2_242 vccd1 vssd1 X2_sky130_fd_sc_hd__tapvpwrvgnd_1
XFILLER_74_249 vssd1 vccd1 vccd1 vssd1 X2_sky130_fd_sc_hd__fill_2
XFILLER_15_305 vssd1 vccd1 vssd1 vccd1 X2_sky130_ef_sc_hd__decap_40_12
XFILLER_27_165 vssd1 vccd1 vccd1 vssd1 X2_sky130_fd_sc_hd__fill_2
XFILLER_35_11 vssd1 vccd1 vssd1 vccd1 X2_sky130_ef_sc_hd__decap_40_12
XFILLER_55_485 vssd1 vccd1 vssd1 vccd1 X2_sky130_ef_sc_hd__decap_40_12
XFILLER_43_614 vssd1 vccd1 vccd1 vssd1 X2_sky130_fd_sc_hd__fill_2
XFILLER_15_349 vssd1 vccd1 vssd1 vccd1 X2_sky130_ef_sc_hd__decap_40_12
XFILLER_35_55 vccd1 vssd1 vccd1 vssd1 X2_sky130_fd_sc_hd__fill_1
XANTENNA__518__A _521_/A vssd1 vccd1 vccd1 vssd1 X2_sky130_fd_sc_hd__diode_2
XFILLER_70_433 vssd1 vccd1 vssd1 vccd1 X2_sky130_ef_sc_hd__decap_40_12
XFILLER_70_477 vssd1 vccd1 vssd1 vccd1 X2_sky130_ef_sc_hd__decap_40_12
XFILLER_23_393 vssd1 vccd1 vssd1 vccd1 X2_sky130_ef_sc_hd__decap_40_12
XFILLER_7_559 vccd1 vssd1 vccd1 vssd1 X2_sky130_fd_sc_hd__fill_1
XFILLER_2_253 vssd1 vccd1 vssd1 vccd1 X2_sky130_ef_sc_hd__decap_40_12
XFILLER_78_533 vssd1 vccd1 vssd1 vccd1 X2_sky130_ef_sc_hd__decap_40_12
XFILLER_38_419 vccd1 vssd1 vccd1 vssd1 X2_sky130_fd_sc_hd__fill_1
XFILLER_93_503 vccd1 vssd1 vccd1 vssd1 X2_sky130_fd_sc_hd__fill_1
XFILLER_65_205 vssd1 vccd1 vssd1 vccd1 X2_sky130_ef_sc_hd__decap_40_12
XFILLER_18_121 vssd1 vccd1 vssd1 vccd1 X2_sky130_ef_sc_hd__decap_40_12
XFILLER_65_249 vssd1 vccd1 vccd1 vssd1 X2_sky130_fd_sc_hd__fill_8
XFILLER_18_165 vssd1 vccd1 vssd1 vccd1 X2_sky130_ef_sc_hd__decap_40_12
XTAP_TAPCELL_ROW_64_929 vccd1 vssd1 X2_sky130_fd_sc_hd__tapvpwrvgnd_1
XFILLER_33_113 vssd1 vccd1 vssd1 vccd1 X2_sky130_ef_sc_hd__decap_40_12
XFILLER_73_293 vssd1 vccd1 vssd1 vccd1 X2_sky130_ef_sc_hd__decap_40_12
XFILLER_92_83 vccd1 vssd1 vccd1 vssd1 X2_sky130_fd_sc_hd__fill_1
XTAP_TAPCELL_ROW_16_399 vccd1 vssd1 X2_sky130_fd_sc_hd__tapvpwrvgnd_1
X_409_ vccd1 vssd1 _409_/X _408_/Y _404_/X _402_/X _426_/B vssd1 vccd1 X2_sky130_fd_sc_hd__a31o_1
XFILLER_6_581 vssd1 vccd1 vccd1 vssd1 X2_sky130_fd_sc_hd__fill_4
XFILLER_96_363 vccd1 vssd1 vccd1 vssd1 X2_sky130_fd_sc_hd__fill_1
XPHY_EDGE_ROW_87_Left_189 vccd1 vssd1 vccd1 vssd1 X2_sky130_fd_sc_hd__decap_3
XFILLER_84_525 vssd1 vccd1 vccd1 vssd1 X2_sky130_fd_sc_hd__fill_4
XFILLER_2_81 vssd1 vccd1 vccd1 vssd1 X2_sky130_fd_sc_hd__fill_2
XFILLER_84_569 vssd1 vccd1 vssd1 vccd1 X2_sky130_ef_sc_hd__decap_40_12
XFILLER_56_249 vssd1 vccd1 vccd1 vssd1 X2_sky130_fd_sc_hd__fill_2
XFILLER_37_474 vssd1 vccd1 vccd1 vssd1 X2_sky130_fd_sc_hd__fill_2
XFILLER_52_477 vccd1 vssd1 vccd1 vssd1 X2_sky130_fd_sc_hd__fill_1
XPHY_EDGE_ROW_96_Left_198 vccd1 vssd1 vccd1 vssd1 X2_sky130_fd_sc_hd__decap_3
XFILLER_20_363 vccd1 vssd1 vccd1 vssd1 X2_sky130_fd_sc_hd__fill_1
XFILLER_4_529 vssd1 vccd1 vccd1 vssd1 X2_sky130_fd_sc_hd__fill_2
XFILLER_21_57 vssd1 vccd1 vssd1 vccd1 X2_sky130_ef_sc_hd__decap_40_12
XTAP_TAPCELL_ROW_76_1054 vccd1 vssd1 X2_sky130_fd_sc_hd__tapvpwrvgnd_1
XTAP_TAPCELL_ROW_7_301 vccd1 vssd1 X2_sky130_fd_sc_hd__tapvpwrvgnd_1
XFILLER_97_39 vssd1 vccd1 vssd1 vccd1 X2_sky130_ef_sc_hd__decap_40_12
XFILLER_87_352 vssd1 vccd1 vccd1 vssd1 X2_sky130_fd_sc_hd__fill_4
XFILLER_75_503 vccd1 vssd1 vccd1 vssd1 X2_sky130_fd_sc_hd__fill_1
XFILLER_101_195 vccd1 vssd1 vccd1 vssd1 X2_sky130_fd_sc_hd__fill_1
XFILLER_46_65 vssd1 vccd1 vssd1 vccd1 X2_sky130_ef_sc_hd__decap_40_12
XFILLER_15_113 vssd1 vccd1 vssd1 vccd1 X2_sky130_ef_sc_hd__decap_40_12
XTAP_TAPCELL_ROW_87_1172 vccd1 vssd1 X2_sky130_fd_sc_hd__tapvpwrvgnd_1
XFILLER_31_617 vssd1 vccd1 vccd1 vssd1 X2_sky130_fd_sc_hd__fill_4
XFILLER_62_53 vssd1 vccd1 vssd1 vccd1 X2_sky130_ef_sc_hd__decap_40_12
XTAP_TAPCELL_ROW_13_358 vccd1 vssd1 X2_sky130_fd_sc_hd__tapvpwrvgnd_1
XTAP_TAPCELL_ROW_41_667 vccd1 vssd1 X2_sky130_fd_sc_hd__tapvpwrvgnd_1
XFILLER_62_97 vssd1 vccd1 vssd1 vccd1 X2_sky130_ef_sc_hd__decap_40_12
XFILLER_7_15 vssd1 vccd1 vssd1 vccd1 X2_sky130_ef_sc_hd__decap_40_12
XFILLER_11_385 vssd1 vccd1 vccd1 vssd1 X2_sky130_fd_sc_hd__fill_4
XFILLER_7_389 vssd1 vccd1 vccd1 vssd1 X2_sky130_fd_sc_hd__fill_2
XFILLER_3_573 vssd1 vccd1 vssd1 vccd1 X2_sky130_ef_sc_hd__decap_40_12
XFILLER_97_105 vssd1 vccd1 vccd1 vssd1 X2_sky130_fd_sc_hd__fill_4
XFILLER_97_149 vssd1 vccd1 vssd1 vccd1 X2_sky130_ef_sc_hd__decap_40_12
XFILLER_78_363 vccd1 vssd1 vccd1 vssd1 X2_sky130_fd_sc_hd__fill_1
XFILLER_66_525 vssd1 vccd1 vccd1 vssd1 X2_sky130_fd_sc_hd__fill_4
XFILLER_19_441 vssd1 vccd1 vccd1 vssd1 X2_sky130_fd_sc_hd__fill_4
XFILLER_38_249 vssd1 vccd1 vccd1 vssd1 X2_sky130_fd_sc_hd__fill_2
XFILLER_66_569 vssd1 vccd1 vssd1 vccd1 X2_sky130_ef_sc_hd__decap_40_12
XTAP_TAPCELL_ROW_49_756 vccd1 vssd1 X2_sky130_fd_sc_hd__tapvpwrvgnd_1
XFILLER_93_388 vssd1 vccd1 vccd1 vssd1 X2_sky130_fd_sc_hd__fill_4
XFILLER_81_517 vssd1 vccd1 vssd1 vccd1 X2_sky130_ef_sc_hd__decap_40_12
XFILLER_19_485 vssd1 vccd1 vssd1 vccd1 X2_sky130_ef_sc_hd__decap_40_12
XFILLER_34_477 vccd1 vssd1 vccd1 vssd1 X2_sky130_fd_sc_hd__fill_1
XFILLER_21_105 vssd1 vccd1 vccd1 vssd1 X2_sky130_fd_sc_hd__fill_4
XFILLER_61_274 vssd1 vccd1 vccd1 vssd1 X2_sky130_fd_sc_hd__fill_4
XFILLER_21_149 vssd1 vccd1 vssd1 vccd1 X2_sky130_ef_sc_hd__decap_40_12
Xinput40 vssd1 vccd1 wbs_we_i _303_/A vccd1 vssd1 X2_sky130_fd_sc_hd__clkbuf_2
XFILLER_89_617 vssd1 vccd1 vccd1 vssd1 X2_sky130_fd_sc_hd__fill_8
XANTENNA__554__CLK _601_/CLK vssd1 vccd1 vccd1 vssd1 X2_sky130_fd_sc_hd__diode_2
XFILLER_57_503 vccd1 vssd1 vccd1 vssd1 X2_sky130_fd_sc_hd__fill_1
XFILLER_29_205 vssd1 vccd1 vssd1 vccd1 X2_sky130_ef_sc_hd__decap_40_12
XFILLER_84_300 vssd1 vccd1 vccd1 vssd1 X2_sky130_fd_sc_hd__fill_2
XFILLER_69_385 vssd1 vccd1 vccd1 vssd1 X2_sky130_fd_sc_hd__fill_4
XFILLER_29_249 vssd1 vccd1 vssd1 vccd1 X2_sky130_ef_sc_hd__decap_40_12
XFILLER_96_193 vssd1 vccd1 vccd1 vssd1 X2_sky130_fd_sc_hd__fill_2
XFILLER_84_377 vssd1 vccd1 vssd1 vccd1 X2_sky130_ef_sc_hd__decap_40_12
XFILLER_37_271 vssd1 vccd1 vccd1 vssd1 X2_sky130_fd_sc_hd__fill_8
XFILLER_65_591 vssd1 vccd1 vccd1 vssd1 X2_sky130_fd_sc_hd__fill_2
XFILLER_13_617 vssd1 vccd1 vccd1 vssd1 X2_sky130_fd_sc_hd__fill_8
XFILLER_8_109 vssd1 vccd1 vssd1 vccd1 X2_sky130_ef_sc_hd__decap_40_12
XFILLER_40_469 vssd1 vccd1 vccd1 vssd1 X2_sky130_fd_sc_hd__fill_4
XTAP_TAPCELL_ROW_10_328 vccd1 vssd1 X2_sky130_fd_sc_hd__tapvpwrvgnd_1
XFILLER_20_193 vssd1 vccd1 vccd1 vssd1 X2_sky130_fd_sc_hd__fill_2
XFILLER_79_105 vssd1 vccd1 vccd1 vssd1 X2_sky130_fd_sc_hd__fill_4
XFILLER_95_609 vssd1 vccd1 vccd1 vssd1 X2_sky130_fd_sc_hd__fill_4
XFILLER_79_149 vssd1 vccd1 vssd1 vccd1 X2_sky130_ef_sc_hd__decap_40_12
XFILLER_0_587 vccd1 vssd1 vccd1 vssd1 X2_sky130_fd_sc_hd__fill_1
XTAP_TAPCELL_ROW_89_1201 vccd1 vssd1 X2_sky130_fd_sc_hd__tapvpwrvgnd_1
XFILLER_87_193 vssd1 vccd1 vssd1 vccd1 X2_sky130_ef_sc_hd__decap_40_12
XANTENNA_input26_A wbs_dat_i[12] vssd1 vccd1 vccd1 vssd1 X2_sky130_fd_sc_hd__diode_2
XFILLER_75_333 vssd1 vccd1 vccd1 vssd1 X2_sky130_fd_sc_hd__fill_2
XFILLER_48_569 vssd1 vccd1 vccd1 vssd1 X2_sky130_fd_sc_hd__fill_2
XFILLER_90_303 vccd1 vssd1 vccd1 vssd1 X2_sky130_fd_sc_hd__fill_1
XFILLER_63_517 vssd1 vccd1 vssd1 vccd1 X2_sky130_ef_sc_hd__decap_40_12
XFILLER_16_433 vssd1 vccd1 vssd1 vccd1 X2_sky130_ef_sc_hd__decap_40_12
XTAP_TAPCELL_ROW_18_417 vccd1 vssd1 X2_sky130_fd_sc_hd__tapvpwrvgnd_1
XFILLER_28_293 vssd1 vccd1 vssd1 vccd1 X2_sky130_ef_sc_hd__decap_40_12
XTAP_TAPCELL_ROW_46_726 vccd1 vssd1 X2_sky130_fd_sc_hd__tapvpwrvgnd_1
XFILLER_71_561 vssd1 vccd1 vssd1 vccd1 X2_sky130_ef_sc_hd__decap_40_12
XFILLER_16_477 vssd1 vccd1 vssd1 vccd1 X2_sky130_ef_sc_hd__decap_40_12
XFILLER_31_447 vccd1 vssd1 vccd1 vssd1 X2_sky130_fd_sc_hd__fill_1
XFILLER_11_193 vssd1 vccd1 vssd1 vccd1 X2_sky130_ef_sc_hd__decap_40_12
XFILLER_98_447 vssd1 vccd1 vssd1 vccd1 X2_sky130_ef_sc_hd__decap_40_12
XFILLER_21_3 vssd1 vccd1 vssd1 vccd1 X2_sky130_ef_sc_hd__decap_40_12
XFILLER_39_503 vccd1 vssd1 vccd1 vssd1 X2_sky130_fd_sc_hd__fill_1
XFILLER_100_419 vccd1 vssd1 vccd1 vssd1 X2_sky130_fd_sc_hd__fill_1
XFILLER_78_193 vssd1 vccd1 vccd1 vssd1 X2_sky130_fd_sc_hd__fill_2
XFILLER_66_333 vssd1 vccd1 vssd1 vccd1 X2_sky130_ef_sc_hd__decap_40_12
XFILLER_66_377 vssd1 vccd1 vssd1 vccd1 X2_sky130_ef_sc_hd__decap_40_12
XFILLER_19_293 vssd1 vccd1 vssd1 vccd1 X2_sky130_ef_sc_hd__decap_40_12
XFILLER_62_561 vssd1 vccd1 vccd1 vssd1 X2_sky130_fd_sc_hd__fill_2
XFILLER_34_296 vssd1 vccd1 vccd1 vssd1 X2_sky130_fd_sc_hd__fill_2
XFILLER_22_469 vssd1 vccd1 vccd1 vssd1 X2_sky130_fd_sc_hd__fill_4
XFILLER_89_447 vccd1 vssd1 vccd1 vssd1 X2_sky130_fd_sc_hd__fill_1
XTAP_TAPCELL_ROW_73_1024 vccd1 vssd1 X2_sky130_fd_sc_hd__tapvpwrvgnd_1
XFILLER_77_609 vssd1 vccd1 vccd1 vssd1 X2_sky130_fd_sc_hd__fill_4
XFILLER_94_29 vssd1 vccd1 vssd1 vccd1 X2_sky130_ef_sc_hd__decap_40_12
XFILLER_69_193 vssd1 vccd1 vssd1 vccd1 X2_sky130_ef_sc_hd__decap_40_12
XFILLER_84_141 vssd1 vccd1 vssd1 vccd1 X2_sky130_ef_sc_hd__decap_40_12
XFILLER_45_517 vssd1 vccd1 vccd1 vssd1 X2_sky130_fd_sc_hd__fill_2
XTAP_TAPCELL_ROW_84_1142 vccd1 vssd1 X2_sky130_fd_sc_hd__tapvpwrvgnd_1
XFILLER_40_200 vssd1 vccd1 vccd1 vssd1 X2_sky130_fd_sc_hd__fill_4
XFILLER_53_561 vccd1 vssd1 vccd1 vssd1 X2_sky130_fd_sc_hd__fill_1
X_390_ vssd1 vccd1 _414_/B _392_/B _390_/A vccd1 vssd1 X2_sky130_fd_sc_hd__xnor2_1
XFILLER_13_447 vccd1 vssd1 vccd1 vssd1 X2_sky130_fd_sc_hd__fill_1
XANTENNA__526__A _527_/A vssd1 vccd1 vccd1 vssd1 X2_sky130_fd_sc_hd__diode_2
XFILLER_43_55 vccd1 vssd1 vccd1 vssd1 X2_sky130_fd_sc_hd__fill_1
XFILLER_9_429 vssd1 vccd1 vssd1 vccd1 X2_sky130_ef_sc_hd__decap_40_12
XFILLER_40_277 vccd1 vssd1 vccd1 vssd1 X2_sky130_fd_sc_hd__fill_1
XTAP_TAPCELL_ROW_23_475 vccd1 vssd1 X2_sky130_fd_sc_hd__tapvpwrvgnd_1
XTAP_TAPCELL_ROW_51_784 vccd1 vssd1 X2_sky130_fd_sc_hd__tapvpwrvgnd_1
XFILLER_5_613 vssd1 vccd1 vccd1 vssd1 X2_sky130_fd_sc_hd__fill_2
XTAP_TAPCELL_ROW_95_1260 vccd1 vssd1 X2_sky130_fd_sc_hd__tapvpwrvgnd_1
XFILLER_4_27 vccd1 vssd1 vccd1 vssd1 X2_sky130_fd_sc_hd__fill_1
XFILLER_4_189 vssd1 vccd1 vccd1 vssd1 X2_sky130_fd_sc_hd__fill_4
XFILLER_68_41 vssd1 vccd1 vssd1 vccd1 X2_sky130_ef_sc_hd__decap_40_12
XFILLER_0_362 vssd1 vccd1 vccd1 vssd1 X2_sky130_fd_sc_hd__fill_2
XFILLER_95_417 vssd1 vccd1 vssd1 vccd1 X2_sky130_ef_sc_hd__decap_40_12
XFILLER_68_85 vssd1 vccd1 vssd1 vccd1 X2_sky130_ef_sc_hd__decap_40_12
XFILLER_48_333 vssd1 vccd1 vccd1 vssd1 X2_sky130_fd_sc_hd__fill_8
XFILLER_36_517 vccd1 vssd1 vccd1 vssd1 X2_sky130_fd_sc_hd__fill_1
XTAP_TAPCELL_ROW_59_873 vccd1 vssd1 X2_sky130_fd_sc_hd__tapvpwrvgnd_1
XFILLER_48_388 vccd1 vssd1 vccd1 vssd1 X2_sky130_fd_sc_hd__fill_1
XFILLER_90_133 vssd1 vccd1 vccd1 vssd1 X2_sky130_fd_sc_hd__fill_4
X_588_ vssd1 vccd1 vccd1 vssd1 _597_/CLK _588_/D _508_/Y _588_/Q X2_sky130_fd_sc_hd__dfrtp_1
XFILLER_90_177 vssd1 vccd1 vssd1 vccd1 X2_sky130_ef_sc_hd__decap_40_12
XFILLER_44_583 vssd1 vccd1 vccd1 vssd1 X2_sky130_fd_sc_hd__fill_2
XFILLER_71_391 vccd1 vssd1 vccd1 vssd1 X2_sky130_fd_sc_hd__fill_1
XFILLER_31_277 vssd1 vccd1 vccd1 vssd1 X2_sky130_fd_sc_hd__fill_2
XFILLER_8_473 vssd1 vccd1 vccd1 vssd1 X2_sky130_fd_sc_hd__fill_2
XFILLER_69_3 vssd1 vccd1 vssd1 vccd1 X2_sky130_ef_sc_hd__decap_40_12
XFILLER_98_233 vssd1 vccd1 vssd1 vccd1 X2_sky130_ef_sc_hd__decap_40_12
XFILLER_98_277 vssd1 vccd1 vssd1 vccd1 X2_sky130_ef_sc_hd__decap_40_12
XFILLER_86_417 vssd1 vccd1 vccd1 vssd1 X2_sky130_fd_sc_hd__fill_2
XFILLER_100_249 vssd1 vccd1 vccd1 vssd1 X2_sky130_fd_sc_hd__fill_2
XFILLER_27_517 vssd1 vccd1 vssd1 vccd1 X2_sky130_ef_sc_hd__decap_40_12
XFILLER_82_601 vssd1 vccd1 vssd1 vccd1 X2_sky130_ef_sc_hd__decap_40_12
XFILLER_66_141 vssd1 vccd1 vssd1 vccd1 X2_sky130_ef_sc_hd__decap_40_12
XFILLER_81_111 vccd1 vssd1 vccd1 vssd1 X2_sky130_fd_sc_hd__fill_1
XFILLER_54_325 vccd1 vssd1 vccd1 vssd1 X2_sky130_fd_sc_hd__fill_1
XFILLER_35_561 vccd1 vssd1 vccd1 vssd1 X2_sky130_fd_sc_hd__fill_1
XFILLER_22_233 vssd1 vccd1 vssd1 vccd1 X2_sky130_ef_sc_hd__decap_40_12
XFILLER_10_417 vssd1 vccd1 vccd1 vssd1 X2_sky130_fd_sc_hd__fill_2
XFILLER_22_277 vssd1 vccd1 vssd1 vccd1 X2_sky130_ef_sc_hd__decap_40_12
XFILLER_50_586 vssd1 vccd1 vccd1 vssd1 X2_sky130_fd_sc_hd__fill_2
XFILLER_50_575 vssd1 vccd1 vccd1 vssd1 X2_sky130_fd_sc_hd__fill_2
XFILLER_13_69 vssd1 vccd1 vssd1 vccd1 X2_sky130_ef_sc_hd__decap_40_12
XTAP_TAPCELL_ROW_20_445 vccd1 vssd1 X2_sky130_fd_sc_hd__tapvpwrvgnd_1
XFILLER_1_137 vssd1 vccd1 vssd1 vccd1 X2_sky130_ef_sc_hd__decap_40_12
XFILLER_89_277 vssd1 vccd1 vccd1 vssd1 X2_sky130_fd_sc_hd__fill_2
XFILLER_77_417 vssd1 vccd1 vssd1 vccd1 X2_sky130_ef_sc_hd__decap_40_12
XFILLER_38_77 vssd1 vccd1 vccd1 vssd1 X2_sky130_fd_sc_hd__fill_4
XFILLER_85_461 vssd1 vccd1 vssd1 vccd1 X2_sky130_ef_sc_hd__decap_40_12
XTAP_TAPCELL_ROW_28_523 vccd1 vssd1 X2_sky130_fd_sc_hd__tapvpwrvgnd_1
XTAP_TAPCELL_ROW_56_832 vccd1 vssd1 X2_sky130_fd_sc_hd__tapvpwrvgnd_1
XFILLER_72_133 vssd1 vccd1 vccd1 vssd1 X2_sky130_fd_sc_hd__fill_4
X_511_ vccd1 vssd1 vccd1 vssd1 _511_/Y _527_/A X2_sky130_fd_sc_hd__inv_2
XFILLER_72_177 vssd1 vccd1 vssd1 vccd1 X2_sky130_ef_sc_hd__decap_40_12
XFILLER_60_317 vssd1 vccd1 vccd1 vssd1 X2_sky130_fd_sc_hd__fill_2
XFILLER_54_65 vssd1 vccd1 vssd1 vccd1 X2_sky130_ef_sc_hd__decap_40_12
X_442_ vssd1 vccd1 _573_/Q _608_/Q _442_/X _575_/Q hold1/X vccd1 vssd1 X2_sky130_fd_sc_hd__and4b_1
X_373_ _379_/C _373_/C _373_/A _373_/B _373_/D vssd1 vccd1 vccd1 vssd1 X2_sky130_fd_sc_hd__and4_1
XFILLER_9_237 vssd1 vccd1 vssd1 vccd1 X2_sky130_ef_sc_hd__decap_40_12
XFILLER_13_277 vssd1 vccd1 vccd1 vssd1 X2_sky130_fd_sc_hd__fill_2
XFILLER_70_53 vssd1 vccd1 vssd1 vccd1 X2_sky130_ef_sc_hd__decap_40_12
XFILLER_70_97 vssd1 vccd1 vssd1 vccd1 X2_sky130_ef_sc_hd__decap_40_12
XFILLER_79_51 vssd1 vccd1 vccd1 vssd1 X2_sky130_fd_sc_hd__fill_4
XFILLER_68_417 vssd1 vccd1 vccd1 vssd1 X2_sky130_fd_sc_hd__fill_2
XFILLER_0_181 vssd1 vccd1 vccd1 vssd1 X2_sky130_fd_sc_hd__fill_8
XFILLER_95_225 vssd1 vccd1 vssd1 vccd1 X2_sky130_ef_sc_hd__decap_40_12
XFILLER_48_141 vssd1 vccd1 vssd1 vccd1 X2_sky130_ef_sc_hd__decap_40_12
XFILLER_63_111 vccd1 vssd1 vccd1 vssd1 X2_sky130_fd_sc_hd__fill_1
XFILLER_17_561 vssd1 vccd1 vssd1 vccd1 X2_sky130_ef_sc_hd__decap_40_12
XFILLER_91_497 vssd1 vccd1 vccd1 vssd1 X2_sky130_fd_sc_hd__fill_4
XFILLER_51_317 vssd1 vccd1 vccd1 vssd1 X2_sky130_fd_sc_hd__fill_2
XFILLER_32_531 vccd1 vssd1 vccd1 vssd1 X2_sky130_fd_sc_hd__fill_1
XFILLER_32_586 vssd1 vccd1 vccd1 vssd1 X2_sky130_fd_sc_hd__fill_2
XFILLER_5_81 vssd1 vccd1 vssd1 vccd1 X2_sky130_ef_sc_hd__decap_40_12
XFILLER_99_553 vssd1 vccd1 vccd1 vssd1 X2_sky130_fd_sc_hd__fill_4
XFILLER_101_503 vccd1 vssd1 vccd1 vssd1 X2_sky130_fd_sc_hd__fill_1
XFILLER_99_597 vssd1 vccd1 vssd1 vccd1 X2_sky130_ef_sc_hd__decap_40_12
XFILLER_59_417 vssd1 vccd1 vssd1 vccd1 X2_sky130_ef_sc_hd__decap_40_12
XFILLER_67_461 vssd1 vccd1 vssd1 vccd1 X2_sky130_ef_sc_hd__decap_40_12
XFILLER_55_612 vccd1 vssd1 vccd1 vssd1 X2_sky130_fd_sc_hd__fill_1
XFILLER_54_133 vssd1 vccd1 vccd1 vssd1 X2_sky130_fd_sc_hd__fill_4
XFILLER_82_475 vccd1 vssd1 vccd1 vssd1 X2_sky130_fd_sc_hd__fill_1
XFILLER_70_604 vssd1 vccd1 vssd1 vccd1 X2_sky130_ef_sc_hd__decap_40_12
XFILLER_54_177 vssd1 vccd1 vssd1 vccd1 X2_sky130_ef_sc_hd__decap_40_12
XTAP_TAPCELL_ROW_53_802 vccd1 vssd1 X2_sky130_fd_sc_hd__tapvpwrvgnd_1
XFILLER_42_317 vssd1 vccd1 vccd1 vssd1 X2_sky130_fd_sc_hd__fill_2
XFILLER_35_391 vccd1 vssd1 vccd1 vssd1 X2_sky130_fd_sc_hd__fill_1
XTAP_TAPCELL_ROW_81_1112 vccd1 vssd1 X2_sky130_fd_sc_hd__tapvpwrvgnd_1
XFILLER_42_339 vssd1 vccd1 vccd1 vssd1 X2_sky130_fd_sc_hd__fill_2
XFILLER_23_553 vssd1 vccd1 vccd1 vssd1 X2_sky130_fd_sc_hd__fill_4
XFILLER_50_350 vssd1 vccd1 vssd1 vccd1 X2_sky130_ef_sc_hd__decap_40_12
XFILLER_23_597 vssd1 vccd1 vssd1 vccd1 X2_sky130_ef_sc_hd__decap_40_12
XTAP_TAPCELL_ROW_33_581 vccd1 vssd1 X2_sky130_fd_sc_hd__tapvpwrvgnd_1
XTAP_TAPCELL_ROW_61_890 vccd1 vssd1 X2_sky130_fd_sc_hd__tapvpwrvgnd_1
XTAP_TAPCELL_ROW_79_1085 vccd1 vssd1 X2_sky130_fd_sc_hd__tapvpwrvgnd_1
XFILLER_2_413 vssd1 vccd1 vccd1 vssd1 X2_sky130_fd_sc_hd__fill_4
XFILLER_2_457 vssd1 vccd1 vssd1 vccd1 X2_sky130_ef_sc_hd__decap_40_12
XTAP_TAPCELL_ROW_92_1230 vccd1 vssd1 X2_sky130_fd_sc_hd__tapvpwrvgnd_1
XFILLER_77_225 vssd1 vccd1 vssd1 vccd1 X2_sky130_ef_sc_hd__decap_40_12
XTAP_TAPCELL_ROW_5_273 vccd1 vssd1 X2_sky130_fd_sc_hd__tapvpwrvgnd_1
XFILLER_1_39 vssd1 vccd1 vssd1 vccd1 X2_sky130_ef_sc_hd__decap_40_12
XFILLER_46_612 vccd1 vssd1 vccd1 vssd1 X2_sky130_fd_sc_hd__fill_1
XFILLER_45_111 vccd1 vssd1 vccd1 vssd1 X2_sky130_fd_sc_hd__fill_1
XFILLER_61_604 vssd1 vccd1 vccd1 vssd1 X2_sky130_fd_sc_hd__fill_2
XFILLER_14_531 vccd1 vssd1 vccd1 vssd1 X2_sky130_fd_sc_hd__fill_1
XFILLER_73_497 vssd1 vccd1 vccd1 vssd1 X2_sky130_fd_sc_hd__fill_4
X_425_ vssd1 vccd1 _425_/C _422_/B _425_/X _425_/D _425_/B vccd1 vssd1 X2_sky130_fd_sc_hd__and4b_1
X_356_ vccd1 vssd1 _422_/B _555_/Q _356_/A vccd1 vssd1 X2_sky130_fd_sc_hd__and2_1
XFILLER_41_383 vssd1 vccd1 vccd1 vssd1 X2_sky130_fd_sc_hd__fill_2
XFILLER_41_372 vssd1 vccd1 vccd1 vssd1 X2_sky130_fd_sc_hd__fill_2
X_287_ vssd1 vccd1 vccd1 vssd1 _592_/D hold32/X _289_/S _297_/A0 X2_sky130_fd_sc_hd__mux2_1
XFILLER_5_273 vssd1 vccd1 vccd1 vssd1 X2_sky130_fd_sc_hd__fill_4
XANTENNA__297__A0 _297_/A0 vssd1 vccd1 vccd1 vssd1 X2_sky130_fd_sc_hd__diode_2
XFILLER_96_501 vssd1 vccd1 vssd1 vccd1 X2_sky130_ef_sc_hd__decap_40_12
XFILLER_96_545 vssd1 vccd1 vssd1 vccd1 X2_sky130_ef_sc_hd__decap_40_12
XFILLER_96_589 vssd1 vccd1 vssd1 vccd1 X2_sky130_ef_sc_hd__decap_40_12
Xinput5 vssd1 vccd1 _532_/D adc_data_in[2] vccd1 vssd1 X2_sky130_fd_sc_hd__buf_1
XFILLER_83_217 vssd1 vccd1 vccd1 vssd1 X2_sky130_fd_sc_hd__fill_4
XFILLER_36_133 vssd1 vccd1 vccd1 vssd1 X2_sky130_fd_sc_hd__fill_4
XFILLER_36_177 vssd1 vccd1 vssd1 vccd1 X2_sky130_ef_sc_hd__decap_40_12
XFILLER_91_261 vssd1 vccd1 vssd1 vccd1 X2_sky130_ef_sc_hd__decap_40_12
XFILLER_64_475 vccd1 vssd1 vccd1 vssd1 X2_sky130_fd_sc_hd__fill_1
XFILLER_17_391 vccd1 vssd1 vccd1 vssd1 X2_sky130_fd_sc_hd__fill_1
XFILLER_101_29 vssd1 vccd1 vssd1 vccd1 X2_sky130_ef_sc_hd__decap_40_12
XFILLER_51_125 vssd1 vccd1 vssd1 vccd1 X2_sky130_ef_sc_hd__decap_40_12
XFILLER_51_169 vssd1 vccd1 vssd1 vccd1 X2_sky130_ef_sc_hd__decap_40_12
XFILLER_20_501 vssd1 vccd1 vssd1 vccd1 X2_sky130_ef_sc_hd__decap_40_12
XFILLER_20_545 vssd1 vccd1 vssd1 vccd1 X2_sky130_ef_sc_hd__decap_40_12
XFILLER_20_589 vssd1 vccd1 vssd1 vccd1 X2_sky130_ef_sc_hd__decap_40_12
XTAP_TAPCELL_ROW_30_551 vccd1 vssd1 X2_sky130_fd_sc_hd__tapvpwrvgnd_1
XFILLER_10_15 vssd1 vccd1 vssd1 vccd1 X2_sky130_ef_sc_hd__decap_40_12
XANTENNA__288__A0 _298_/A0 vssd1 vccd1 vccd1 vssd1 X2_sky130_fd_sc_hd__diode_2
XFILLER_87_501 vssd1 vccd1 vccd1 vssd1 X2_sky130_fd_sc_hd__fill_2
XFILLER_99_350 vssd1 vccd1 vccd1 vssd1 X2_sky130_fd_sc_hd__fill_4
XFILLER_101_300 vssd1 vccd1 vccd1 vssd1 X2_sky130_fd_sc_hd__fill_2
XFILLER_59_225 vssd1 vccd1 vssd1 vccd1 X2_sky130_ef_sc_hd__decap_40_12
XFILLER_19_57 vssd1 vccd1 vssd1 vccd1 X2_sky130_ef_sc_hd__decap_40_12
XFILLER_28_601 vssd1 vccd1 vssd1 vccd1 X2_sky130_ef_sc_hd__decap_40_12
XFILLER_101_377 vssd1 vccd1 vccd1 vssd1 X2_sky130_fd_sc_hd__fill_4
XTAP_TAPCELL_ROW_2_243 vccd1 vssd1 X2_sky130_fd_sc_hd__tapvpwrvgnd_1
XFILLER_27_111 vccd1 vssd1 vccd1 vssd1 X2_sky130_fd_sc_hd__fill_1
XTAP_TAPCELL_ROW_38_640 vccd1 vssd1 X2_sky130_fd_sc_hd__tapvpwrvgnd_1
XFILLER_15_317 vssd1 vccd1 vssd1 vccd1 X2_sky130_ef_sc_hd__decap_40_12
XFILLER_35_23 vssd1 vccd1 vssd1 vccd1 X2_sky130_ef_sc_hd__decap_40_12
XFILLER_70_401 vssd1 vccd1 vssd1 vccd1 X2_sky130_ef_sc_hd__decap_40_12
XFILLER_70_445 vssd1 vccd1 vssd1 vccd1 X2_sky130_ef_sc_hd__decap_40_12
XFILLER_55_497 vssd1 vccd1 vccd1 vssd1 X2_sky130_fd_sc_hd__fill_4
XFILLER_30_309 vccd1 vssd1 vccd1 vssd1 X2_sky130_fd_sc_hd__fill_1
XFILLER_11_501 vssd1 vccd1 vccd1 vssd1 X2_sky130_fd_sc_hd__fill_2
XFILLER_23_361 vssd1 vccd1 vssd1 vccd1 X2_sky130_ef_sc_hd__decap_40_12
XFILLER_70_489 vssd1 vccd1 vssd1 vccd1 X2_sky130_ef_sc_hd__decap_40_12
XFILLER_7_505 vssd1 vccd1 vssd1 vccd1 X2_sky130_ef_sc_hd__decap_40_12
XFILLER_51_55 vccd1 vssd1 vccd1 vssd1 X2_sky130_fd_sc_hd__fill_1
XFILLER_2_221 vssd1 vccd1 vssd1 vccd1 X2_sky130_ef_sc_hd__decap_40_12
XFILLER_2_265 vssd1 vccd1 vssd1 vccd1 X2_sky130_ef_sc_hd__decap_40_12
XFILLER_78_501 vssd1 vccd1 vssd1 vccd1 X2_sky130_ef_sc_hd__decap_40_12
XFILLER_78_545 vssd1 vccd1 vssd1 vccd1 X2_sky130_ef_sc_hd__decap_40_12
XFILLER_76_41 vssd1 vccd1 vssd1 vccd1 X2_sky130_ef_sc_hd__decap_40_12
XFILLER_78_589 vssd1 vccd1 vssd1 vccd1 X2_sky130_ef_sc_hd__decap_40_12
XFILLER_76_85 vssd1 vccd1 vssd1 vccd1 X2_sky130_ef_sc_hd__decap_40_12
XFILLER_65_217 vssd1 vccd1 vccd1 vssd1 X2_sky130_fd_sc_hd__fill_4
XFILLER_18_133 vssd1 vccd1 vccd1 vssd1 X2_sky130_fd_sc_hd__fill_4
XFILLER_93_559 vccd1 vssd1 vccd1 vssd1 X2_sky130_fd_sc_hd__fill_1
XFILLER_18_177 vssd1 vccd1 vssd1 vccd1 X2_sky130_ef_sc_hd__decap_40_12
XFILLER_80_209 vssd1 vccd1 vssd1 vccd1 X2_sky130_ef_sc_hd__decap_40_12
XFILLER_73_261 vssd1 vccd1 vssd1 vccd1 X2_sky130_ef_sc_hd__decap_40_12
XTAP_TAPCELL_ROW_64_919 vccd1 vssd1 X2_sky130_fd_sc_hd__tapvpwrvgnd_1
XFILLER_46_475 vccd1 vssd1 vccd1 vssd1 X2_sky130_fd_sc_hd__fill_1
XFILLER_33_125 vssd1 vccd1 vssd1 vccd1 X2_sky130_ef_sc_hd__decap_40_12
XFILLER_61_445 vssd1 vccd1 vccd1 vssd1 X2_sky130_fd_sc_hd__fill_2
XFILLER_33_169 vssd1 vccd1 vssd1 vccd1 X2_sky130_ef_sc_hd__decap_40_12
XFILLER_14_361 vssd1 vccd1 vccd1 vssd1 X2_sky130_fd_sc_hd__fill_2
X_408_ vssd1 vccd1 _408_/B _408_/Y _408_/A vccd1 vssd1 X2_sky130_fd_sc_hd__xnor2_1
X_339_ vccd1 vssd1 vccd1 vssd1 _575_/Q _291_/B _339_/X _317_/C hold6/X _303_/X X2_sky130_fd_sc_hd__a221o_1
XFILLER_51_3 vssd1 vccd1 vssd1 vccd1 X2_sky130_ef_sc_hd__decap_40_12
XFILLER_88_309 vssd1 vccd1 vssd1 vccd1 X2_sky130_ef_sc_hd__decap_40_12
XFILLER_69_501 vssd1 vccd1 vccd1 vssd1 X2_sky130_fd_sc_hd__fill_2
XFILLER_96_386 vssd1 vccd1 vssd1 vccd1 X2_sky130_ef_sc_hd__decap_40_12
XFILLER_37_431 vssd1 vccd1 vccd1 vssd1 X2_sky130_fd_sc_hd__fill_2
XFILLER_25_615 vccd1 vssd1 vccd1 vssd1 X2_sky130_fd_sc_hd__fill_1
XFILLER_37_453 vssd1 vccd1 vccd1 vssd1 X2_sky130_fd_sc_hd__fill_2
XTAP_TAPCELL_ROW_35_610 vccd1 vssd1 X2_sky130_fd_sc_hd__tapvpwrvgnd_1
XFILLER_92_581 vssd1 vccd1 vccd1 vssd1 X2_sky130_fd_sc_hd__fill_4
XFILLER_52_423 vccd1 vssd1 vccd1 vssd1 X2_sky130_fd_sc_hd__fill_1
XFILLER_12_309 vssd1 vccd1 vssd1 vccd1 X2_sky130_ef_sc_hd__decap_40_12
XFILLER_21_69 vssd1 vccd1 vssd1 vccd1 X2_sky130_ef_sc_hd__decap_40_12
XTAP_TAPCELL_ROW_76_1055 vccd1 vssd1 X2_sky130_fd_sc_hd__tapvpwrvgnd_1
XTAP_TAPCELL_ROW_7_302 vccd1 vssd1 X2_sky130_fd_sc_hd__tapvpwrvgnd_1
XFILLER_87_331 vssd1 vccd1 vccd1 vssd1 X2_sky130_fd_sc_hd__fill_2
XFILLER_101_141 vssd1 vccd1 vssd1 vccd1 X2_sky130_ef_sc_hd__decap_40_12
XANTENNA_input3_X _541_/D vssd1 vccd1 vccd1 vssd1 X2_sky130_fd_sc_hd__diode_2
XFILLER_75_559 vccd1 vssd1 vccd1 vssd1 X2_sky130_fd_sc_hd__fill_1
XFILLER_28_475 vccd1 vssd1 vccd1 vssd1 X2_sky130_fd_sc_hd__fill_1
XFILLER_90_529 vssd1 vccd1 vccd1 vssd1 X2_sky130_fd_sc_hd__fill_2
XFILLER_62_209 vssd1 vccd1 vccd1 vssd1 X2_sky130_fd_sc_hd__fill_2
XFILLER_55_261 vssd1 vccd1 vssd1 vccd1 X2_sky130_ef_sc_hd__decap_40_12
XFILLER_46_77 vssd1 vccd1 vccd1 vssd1 X2_sky130_fd_sc_hd__fill_4
XFILLER_15_125 vssd1 vccd1 vssd1 vccd1 X2_sky130_ef_sc_hd__decap_40_12
XTAP_TAPCELL_ROW_87_1173 vccd1 vssd1 X2_sky130_fd_sc_hd__tapvpwrvgnd_1
XFILLER_15_169 vssd1 vccd1 vssd1 vccd1 X2_sky130_ef_sc_hd__decap_40_12
XFILLER_70_253 vssd1 vccd1 vssd1 vccd1 X2_sky130_ef_sc_hd__decap_40_12
XFILLER_30_139 vccd1 vssd1 vccd1 vssd1 X2_sky130_fd_sc_hd__fill_1
XFILLER_62_65 vssd1 vccd1 vssd1 vccd1 X2_sky130_ef_sc_hd__decap_40_12
XFILLER_7_27 vssd1 vccd1 vssd1 vccd1 X2_sky130_ef_sc_hd__decap_40_12
XTAP_TAPCELL_ROW_13_359 vccd1 vssd1 X2_sky130_fd_sc_hd__tapvpwrvgnd_1
XTAP_TAPCELL_ROW_41_668 vccd1 vssd1 X2_sky130_fd_sc_hd__tapvpwrvgnd_1
XFILLER_7_335 vccd1 vssd1 vccd1 vssd1 X2_sky130_fd_sc_hd__fill_1
XFILLER_3_541 vssd1 vccd1 vssd1 vccd1 X2_sky130_ef_sc_hd__decap_40_12
XFILLER_3_585 vssd1 vccd1 vssd1 vccd1 X2_sky130_ef_sc_hd__decap_40_12
XFILLER_87_51 vssd1 vccd1 vccd1 vssd1 X2_sky130_fd_sc_hd__fill_4
XTAP_TAPCELL_ROW_49_757 vccd1 vssd1 X2_sky130_fd_sc_hd__tapvpwrvgnd_1
XFILLER_81_529 vssd1 vccd1 vssd1 vccd1 X2_sky130_ef_sc_hd__decap_40_12
XFILLER_19_497 vssd1 vccd1 vccd1 vssd1 X2_sky130_fd_sc_hd__fill_4
XFILLER_46_294 vssd1 vccd1 vssd1 vccd1 X2_sky130_ef_sc_hd__decap_40_12
XFILLER_46_261 vssd1 vccd1 vccd1 vssd1 X2_sky130_fd_sc_hd__fill_8
XFILLER_99_3 vssd1 vccd1 vssd1 vccd1 X2_sky130_ef_sc_hd__decap_40_12
Xinput30 vccd1 vssd1 vccd1 vssd1 _298_/A0 wbs_dat_i[1] X2_sky130_fd_sc_hd__dlymetal6s2s_1
XANTENNA_hold64_A _558_/Q vssd1 vccd1 vccd1 vssd1 X2_sky130_fd_sc_hd__diode_2
XFILLER_88_139 vccd1 vssd1 vccd1 vssd1 X2_sky130_fd_sc_hd__fill_1
XFILLER_29_217 vssd1 vccd1 vccd1 vssd1 X2_sky130_fd_sc_hd__fill_4
XFILLER_84_345 vssd1 vccd1 vccd1 vssd1 X2_sky130_fd_sc_hd__fill_2
XFILLER_57_559 vccd1 vssd1 vccd1 vssd1 X2_sky130_fd_sc_hd__fill_1
XFILLER_84_389 vssd1 vccd1 vssd1 vccd1 X2_sky130_ef_sc_hd__decap_40_12
XFILLER_72_529 vssd1 vccd1 vccd1 vssd1 X2_sky130_fd_sc_hd__fill_2
XFILLER_25_445 vssd1 vccd1 vccd1 vssd1 X2_sky130_fd_sc_hd__fill_2
XFILLER_52_253 vssd1 vccd1 vssd1 vccd1 X2_sky130_ef_sc_hd__decap_40_12
XFILLER_12_139 vccd1 vssd1 vccd1 vssd1 X2_sky130_fd_sc_hd__fill_1
XTAP_TAPCELL_ROW_10_329 vccd1 vssd1 X2_sky130_fd_sc_hd__tapvpwrvgnd_1
XFILLER_4_305 vssd1 vccd1 vccd1 vssd1 X2_sky130_fd_sc_hd__fill_2
XFILLER_0_533 vssd1 vccd1 vssd1 vccd1 X2_sky130_ef_sc_hd__decap_40_12
XFILLER_87_161 vssd1 vccd1 vccd1 vssd1 X2_sky130_fd_sc_hd__fill_4
XTAP_TAPCELL_ROW_89_1202 vccd1 vssd1 X2_sky130_fd_sc_hd__tapvpwrvgnd_1
XFILLER_94_109 vssd1 vccd1 vssd1 vccd1 X2_sky130_ef_sc_hd__decap_40_12
XFILLER_63_529 vssd1 vccd1 vssd1 vccd1 X2_sky130_ef_sc_hd__decap_40_12
XANTENNA_input19_A wbs_adr_i[5] vssd1 vccd1 vccd1 vssd1 X2_sky130_fd_sc_hd__diode_2
XFILLER_16_401 vssd1 vccd1 vssd1 vccd1 X2_sky130_ef_sc_hd__decap_40_12
XTAP_TAPCELL_ROW_18_418 vccd1 vssd1 X2_sky130_fd_sc_hd__tapvpwrvgnd_1
XFILLER_75_389 vssd1 vccd1 vccd1 vssd1 X2_sky130_fd_sc_hd__fill_2
XFILLER_56_592 vssd1 vccd1 vccd1 vssd1 X2_sky130_fd_sc_hd__fill_2
XTAP_TAPCELL_ROW_46_727 vccd1 vssd1 X2_sky130_fd_sc_hd__tapvpwrvgnd_1
XFILLER_16_445 vssd1 vccd1 vssd1 vccd1 X2_sky130_ef_sc_hd__decap_40_12
XFILLER_16_489 vssd1 vccd1 vssd1 vccd1 X2_sky130_ef_sc_hd__decap_40_12
XFILLER_71_573 vssd1 vccd1 vssd1 vccd1 X2_sky130_ef_sc_hd__decap_40_12
XFILLER_11_161 vssd1 vccd1 vccd1 vssd1 X2_sky130_fd_sc_hd__fill_4
XFILLER_7_165 vssd1 vccd1 vccd1 vssd1 X2_sky130_fd_sc_hd__fill_2
XANTENNA__342__C1 _303_/X vssd1 vccd1 vccd1 vssd1 X2_sky130_fd_sc_hd__diode_2
XFILLER_98_83 vccd1 vssd1 vccd1 vssd1 X2_sky130_fd_sc_hd__fill_1
XFILLER_3_393 vssd1 vccd1 vssd1 vccd1 X2_sky130_ef_sc_hd__decap_40_12
XFILLER_98_459 vssd1 vccd1 vssd1 vccd1 X2_sky130_ef_sc_hd__decap_40_12
XFILLER_100_409 vssd1 vccd1 vccd1 vssd1 X2_sky130_fd_sc_hd__fill_8
XFILLER_85_109 vssd1 vccd1 vccd1 vssd1 X2_sky130_fd_sc_hd__fill_2
XFILLER_66_301 vssd1 vccd1 vccd1 vssd1 X2_sky130_fd_sc_hd__fill_4
XFILLER_14_3 vssd1 vccd1 vssd1 vccd1 X2_sky130_ef_sc_hd__decap_40_12
XFILLER_39_559 vccd1 vssd1 vccd1 vssd1 X2_sky130_fd_sc_hd__fill_1
XFILLER_66_345 vssd1 vccd1 vssd1 vccd1 X2_sky130_ef_sc_hd__decap_40_12
XFILLER_26_209 vssd1 vccd1 vssd1 vccd1 X2_sky130_ef_sc_hd__decap_40_12
XFILLER_19_261 vssd1 vccd1 vssd1 vccd1 X2_sky130_ef_sc_hd__decap_40_12
XFILLER_81_337 vssd1 vccd1 vssd1 vccd1 X2_sky130_ef_sc_hd__decap_40_12
XFILLER_66_389 vssd1 vccd1 vssd1 vccd1 X2_sky130_ef_sc_hd__decap_40_12
XFILLER_34_253 vssd1 vccd1 vssd1 vccd1 X2_sky130_ef_sc_hd__decap_40_12
XFILLER_34_275 vccd1 vssd1 vccd1 vssd1 X2_sky130_fd_sc_hd__fill_1
XFILLER_8_81 vssd1 vccd1 vccd1 vssd1 X2_sky130_fd_sc_hd__fill_2
XANTENNA__333__C1 _303_/X vssd1 vccd1 vccd1 vssd1 X2_sky130_fd_sc_hd__diode_2
XTAP_TAPCELL_ROW_73_1025 vccd1 vssd1 X2_sky130_fd_sc_hd__tapvpwrvgnd_1
XFILLER_76_109 vssd1 vccd1 vssd1 vccd1 X2_sky130_ef_sc_hd__decap_40_12
XFILLER_69_161 vssd1 vccd1 vccd1 vssd1 X2_sky130_fd_sc_hd__fill_4
XFILLER_57_345 vssd1 vccd1 vssd1 vccd1 X2_sky130_ef_sc_hd__decap_40_12
XFILLER_57_334 vssd1 vccd1 vccd1 vssd1 X2_sky130_fd_sc_hd__fill_2
XFILLER_84_153 vssd1 vccd1 vssd1 vccd1 X2_sky130_ef_sc_hd__decap_40_12
XFILLER_27_57 vssd1 vccd1 vssd1 vccd1 X2_sky130_ef_sc_hd__decap_40_12
XFILLER_38_581 vssd1 vccd1 vccd1 vssd1 X2_sky130_fd_sc_hd__fill_4
XFILLER_84_197 vssd1 vccd1 vssd1 vccd1 X2_sky130_ef_sc_hd__decap_40_12
XFILLER_57_389 vssd1 vccd1 vccd1 vssd1 X2_sky130_fd_sc_hd__fill_2
XTAP_TAPCELL_ROW_84_1143 vccd1 vssd1 X2_sky130_fd_sc_hd__tapvpwrvgnd_1
XFILLER_53_595 vssd1 vccd1 vssd1 vccd1 X2_sky130_ef_sc_hd__decap_40_12
XTAP_TAPCELL_ROW_23_476 vccd1 vssd1 X2_sky130_fd_sc_hd__tapvpwrvgnd_1
XTAP_TAPCELL_ROW_51_785 vccd1 vssd1 X2_sky130_fd_sc_hd__tapvpwrvgnd_1
XANTENNA__324__C1 _303_/X vssd1 vccd1 vccd1 vssd1 X2_sky130_fd_sc_hd__diode_2
XTAP_TAPCELL_ROW_95_1261 vccd1 vssd1 X2_sky130_fd_sc_hd__tapvpwrvgnd_1
XFILLER_68_53 vssd1 vccd1 vssd1 vccd1 X2_sky130_ef_sc_hd__decap_40_12
XFILLER_95_429 vssd1 vccd1 vssd1 vccd1 X2_sky130_ef_sc_hd__decap_40_12
XFILLER_67_109 vssd1 vccd1 vccd1 vssd1 X2_sky130_fd_sc_hd__fill_2
XFILLER_0_385 vssd1 vccd1 vccd1 vssd1 X2_sky130_fd_sc_hd__fill_2
XFILLER_0_396 vssd1 vccd1 vssd1 vccd1 X2_sky130_ef_sc_hd__decap_40_12
XFILLER_68_97 vssd1 vccd1 vssd1 vccd1 X2_sky130_ef_sc_hd__decap_40_12
XFILLER_36_507 vssd1 vccd1 vccd1 vssd1 X2_sky130_fd_sc_hd__fill_2
XFILLER_91_613 vssd1 vccd1 vccd1 vssd1 X2_sky130_fd_sc_hd__fill_2
XFILLER_84_41 vssd1 vccd1 vssd1 vccd1 X2_sky130_ef_sc_hd__decap_40_12
XTAP_TAPCELL_ROW_59_874 vccd1 vssd1 X2_sky130_fd_sc_hd__tapvpwrvgnd_1
XFILLER_63_337 vssd1 vccd1 vssd1 vccd1 X2_sky130_ef_sc_hd__decap_40_12
XFILLER_84_85 vssd1 vccd1 vssd1 vccd1 X2_sky130_ef_sc_hd__decap_40_12
XFILLER_44_551 vssd1 vccd1 vssd1 vccd1 X2_sky130_ef_sc_hd__decap_40_12
XFILLER_16_253 vssd1 vccd1 vssd1 vccd1 X2_sky130_ef_sc_hd__decap_40_12
X_587_ vssd1 vccd1 vccd1 vssd1 _597_/CLK _587_/D _507_/Y _587_/Q X2_sky130_fd_sc_hd__dfrtp_1
XFILLER_90_189 vssd1 vccd1 vccd1 vssd1 X2_sky130_fd_sc_hd__fill_4
XFILLER_31_223 vccd1 vssd1 vccd1 vssd1 X2_sky130_fd_sc_hd__fill_1
XANTENNA__544__CLK _607_/CLK vssd1 vccd1 vccd1 vssd1 X2_sky130_fd_sc_hd__diode_2
XANTENNA__452__A _473_/A vssd1 vccd1 vccd1 vssd1 X2_sky130_fd_sc_hd__diode_2
XANTENNA__330__A2 _304_/A vssd1 vccd1 vccd1 vssd1 X2_sky130_fd_sc_hd__diode_2
XFILLER_98_245 vssd1 vccd1 vccd1 vssd1 X2_sky130_fd_sc_hd__fill_4
XFILLER_98_289 vssd1 vccd1 vccd1 vssd1 X2_sky130_fd_sc_hd__fill_4
XFILLER_58_109 vssd1 vccd1 vssd1 vccd1 X2_sky130_ef_sc_hd__decap_40_12
XFILLER_66_153 vssd1 vccd1 vssd1 vccd1 X2_sky130_ef_sc_hd__decap_40_12
XFILLER_27_529 vssd1 vccd1 vssd1 vccd1 X2_sky130_ef_sc_hd__decap_40_12
XFILLER_94_473 vssd1 vccd1 vccd1 vssd1 X2_sky130_fd_sc_hd__fill_2
XFILLER_82_613 vssd1 vccd1 vssd1 vccd1 X2_sky130_ef_sc_hd__decap_40_12
XFILLER_66_197 vssd1 vccd1 vssd1 vccd1 X2_sky130_ef_sc_hd__decap_40_12
XFILLER_54_348 vssd1 vccd1 vssd1 vccd1 X2_sky130_ef_sc_hd__decap_40_12
XFILLER_81_167 vccd1 vssd1 vccd1 vssd1 X2_sky130_fd_sc_hd__fill_1
XFILLER_13_15 vssd1 vccd1 vssd1 vccd1 X2_sky130_ef_sc_hd__decap_40_12
XFILLER_22_245 vssd1 vccd1 vccd1 vssd1 X2_sky130_fd_sc_hd__fill_4
XFILLER_22_289 vssd1 vccd1 vssd1 vccd1 X2_sky130_ef_sc_hd__decap_40_12
XTAP_TAPCELL_ROW_20_435 vccd1 vssd1 X2_sky130_fd_sc_hd__tapvpwrvgnd_1
XFILLER_1_105 vssd1 vccd1 vccd1 vssd1 X2_sky130_fd_sc_hd__fill_4
XANTENNA__321__A2 _304_/A vssd1 vccd1 vccd1 vssd1 X2_sky130_fd_sc_hd__diode_2
XFILLER_1_149 vssd1 vccd1 vssd1 vccd1 X2_sky130_ef_sc_hd__decap_40_12
XFILLER_89_223 vccd1 vssd1 vccd1 vssd1 X2_sky130_fd_sc_hd__fill_1
XFILLER_89_289 vssd1 vccd1 vssd1 vccd1 X2_sky130_ef_sc_hd__decap_40_12
XFILLER_77_429 vssd1 vccd1 vssd1 vccd1 X2_sky130_ef_sc_hd__decap_40_12
XFILLER_49_109 vssd1 vccd1 vccd1 vssd1 X2_sky130_fd_sc_hd__fill_2
XFILLER_18_529 vssd1 vccd1 vccd1 vssd1 X2_sky130_fd_sc_hd__fill_2
XFILLER_85_473 vssd1 vccd1 vssd1 vccd1 X2_sky130_ef_sc_hd__decap_40_12
XFILLER_73_613 vssd1 vccd1 vccd1 vssd1 X2_sky130_fd_sc_hd__fill_2
X_510_ vccd1 vssd1 vccd1 vssd1 _510_/Y _517_/A X2_sky130_fd_sc_hd__inv_2
XTAP_TAPCELL_ROW_28_524 vccd1 vssd1 X2_sky130_fd_sc_hd__tapvpwrvgnd_1
XANTENNA__567__CLK _601_/CLK vssd1 vccd1 vccd1 vssd1 X2_sky130_fd_sc_hd__diode_2
XTAP_TAPCELL_ROW_56_833 vccd1 vssd1 X2_sky130_fd_sc_hd__tapvpwrvgnd_1
XFILLER_45_337 vssd1 vccd1 vssd1 vccd1 X2_sky130_ef_sc_hd__decap_40_12
XFILLER_72_189 vssd1 vccd1 vccd1 vssd1 X2_sky130_fd_sc_hd__fill_4
XFILLER_60_307 vccd1 vssd1 vccd1 vssd1 X2_sky130_fd_sc_hd__fill_1
X_441_ vssd1 vccd1 vccd1 vssd1 _441_/X _301_/A0 _440_/Y hold55/X _439_/X X2_sky130_fd_sc_hd__o2bb2a_1
XFILLER_13_223 vccd1 vssd1 vccd1 vssd1 X2_sky130_fd_sc_hd__fill_1
X_372_ vccd1 vssd1 vccd1 vssd1 _262_/Y hold5/A _371_/X _373_/D X2_sky130_fd_sc_hd__a21oi_1
XFILLER_54_77 vssd1 vccd1 vccd1 vssd1 X2_sky130_fd_sc_hd__fill_4
XFILLER_53_381 vccd1 vssd1 vccd1 vssd1 X2_sky130_fd_sc_hd__fill_1
XFILLER_9_205 vssd1 vccd1 vssd1 vccd1 X2_sky130_ef_sc_hd__decap_40_12
XFILLER_41_576 vssd1 vccd1 vssd1 vccd1 X2_sky130_ef_sc_hd__decap_40_12
XFILLER_9_249 vssd1 vccd1 vssd1 vccd1 X2_sky130_ef_sc_hd__decap_40_12
XFILLER_70_65 vssd1 vccd1 vssd1 vccd1 X2_sky130_ef_sc_hd__decap_40_12
XANTENNA__312__A2 _303_/X vssd1 vccd1 vccd1 vssd1 X2_sky130_fd_sc_hd__diode_2
XFILLER_95_237 vssd1 vccd1 vssd1 vccd1 X2_sky130_ef_sc_hd__decap_40_12
XFILLER_95_51 vssd1 vccd1 vccd1 vssd1 X2_sky130_fd_sc_hd__fill_4
XFILLER_48_153 vssd1 vccd1 vssd1 vccd1 X2_sky130_ef_sc_hd__decap_40_12
XFILLER_76_473 vssd1 vccd1 vccd1 vssd1 X2_sky130_fd_sc_hd__fill_2
XFILLER_64_624 vccd1 vssd1 vccd1 vssd1 X2_sky130_fd_sc_hd__fill_1
XFILLER_48_197 vssd1 vccd1 vccd1 vssd1 X2_sky130_fd_sc_hd__fill_8
XFILLER_17_573 vssd1 vccd1 vssd1 vccd1 X2_sky130_ef_sc_hd__decap_40_12
XFILLER_63_167 vccd1 vssd1 vccd1 vssd1 X2_sky130_fd_sc_hd__fill_1
XFILLER_51_329 vccd1 vssd1 vccd1 vssd1 X2_sky130_fd_sc_hd__fill_1
XFILLER_32_521 vssd1 vccd1 vccd1 vssd1 X2_sky130_fd_sc_hd__fill_8
XFILLER_81_3 vssd1 vccd1 vssd1 vccd1 X2_sky130_ef_sc_hd__decap_40_12
XFILLER_5_93 vssd1 vccd1 vssd1 vccd1 X2_sky130_ef_sc_hd__decap_40_12
XFILLER_59_429 vssd1 vccd1 vssd1 vccd1 X2_sky130_ef_sc_hd__decap_40_12
XFILLER_101_559 vccd1 vssd1 vccd1 vssd1 X2_sky130_fd_sc_hd__fill_1
XFILLER_55_602 vssd1 vccd1 vccd1 vssd1 X2_sky130_fd_sc_hd__fill_8
XPHY_EDGE_ROW_19_Left_121 vccd1 vssd1 vccd1 vssd1 X2_sky130_fd_sc_hd__decap_3
XFILLER_67_473 vssd1 vccd1 vssd1 vccd1 X2_sky130_ef_sc_hd__decap_40_12
XFILLER_55_624 vccd1 vssd1 vccd1 vssd1 X2_sky130_fd_sc_hd__fill_1
XFILLER_27_337 vssd1 vccd1 vssd1 vccd1 X2_sky130_ef_sc_hd__decap_40_12
XFILLER_82_421 vssd1 vccd1 vssd1 vccd1 X2_sky130_ef_sc_hd__decap_40_12
XFILLER_70_616 vssd1 vccd1 vccd1 vssd1 X2_sky130_fd_sc_hd__fill_8
XTAP_TAPCELL_ROW_53_803 vccd1 vssd1 X2_sky130_fd_sc_hd__tapvpwrvgnd_1
XFILLER_42_307 vccd1 vssd1 vccd1 vssd1 X2_sky130_fd_sc_hd__fill_1
XTAP_TAPCELL_ROW_81_1113 vccd1 vssd1 X2_sky130_fd_sc_hd__tapvpwrvgnd_1
XFILLER_54_189 vssd1 vccd1 vccd1 vssd1 X2_sky130_fd_sc_hd__fill_4
XFILLER_50_362 vssd1 vccd1 vccd1 vssd1 X2_sky130_fd_sc_hd__fill_2
XPHY_EDGE_ROW_28_Left_130 vccd1 vssd1 vccd1 vssd1 X2_sky130_fd_sc_hd__decap_3
XTAP_TAPCELL_ROW_33_582 vccd1 vssd1 X2_sky130_fd_sc_hd__tapvpwrvgnd_1
XTAP_TAPCELL_ROW_61_891 vccd1 vssd1 X2_sky130_fd_sc_hd__tapvpwrvgnd_1
XFILLER_50_395 vccd1 vssd1 vccd1 vssd1 X2_sky130_fd_sc_hd__fill_1
XTAP_TAPCELL_ROW_79_1086 vccd1 vssd1 X2_sky130_fd_sc_hd__tapvpwrvgnd_1
XTAP_TAPCELL_ROW_92_1231 vccd1 vssd1 X2_sky130_fd_sc_hd__tapvpwrvgnd_1
XFILLER_2_469 vssd1 vccd1 vccd1 vssd1 X2_sky130_fd_sc_hd__fill_4
XFILLER_49_55 vccd1 vssd1 vccd1 vssd1 X2_sky130_fd_sc_hd__fill_1
XFILLER_77_237 vssd1 vccd1 vssd1 vccd1 X2_sky130_ef_sc_hd__decap_40_12
XTAP_TAPCELL_ROW_5_274 vccd1 vssd1 X2_sky130_fd_sc_hd__tapvpwrvgnd_1
XFILLER_100_581 vssd1 vccd1 vccd1 vssd1 X2_sky130_fd_sc_hd__fill_4
XTAP_TAPCELL_ROW_69_980 vccd1 vssd1 X2_sky130_fd_sc_hd__tapvpwrvgnd_1
XFILLER_58_473 vssd1 vccd1 vccd1 vssd1 X2_sky130_fd_sc_hd__fill_2
XFILLER_85_281 vssd1 vccd1 vssd1 vccd1 X2_sky130_ef_sc_hd__decap_40_12
XFILLER_45_167 vccd1 vssd1 vccd1 vssd1 X2_sky130_fd_sc_hd__fill_1
XFILLER_60_137 vssd1 vccd1 vccd1 vssd1 X2_sky130_fd_sc_hd__fill_2
X_424_ vssd1 vccd1 vssd1 vccd1 _424_/X _415_/X _419_/X _421_/X _423_/Y X2_sky130_fd_sc_hd__o211a_1
XANTENNA__445__A1_N _297_/A0 vssd1 vccd1 vccd1 vssd1 X2_sky130_fd_sc_hd__diode_2
XFILLER_14_587 vccd1 vssd1 vccd1 vssd1 X2_sky130_fd_sc_hd__fill_1
X_355_ vssd1 vccd1 vssd1 vccd1 _355_/X _400_/B _406_/B _406_/A X2_sky130_fd_sc_hd__a21bo_1
X_286_ vssd1 vccd1 vccd1 vssd1 _593_/D hold24/X _289_/S _446_/A1 X2_sky130_fd_sc_hd__mux2_1
XFILLER_96_513 vssd1 vccd1 vssd1 vccd1 X2_sky130_ef_sc_hd__decap_40_12
XFILLER_96_557 vssd1 vccd1 vssd1 vccd1 X2_sky130_ef_sc_hd__decap_40_12
Xinput6 vssd1 vccd1 _533_/D adc_data_in[3] vccd1 vssd1 X2_sky130_fd_sc_hd__buf_1
XFILLER_37_624 vccd1 vssd1 vccd1 vssd1 X2_sky130_fd_sc_hd__fill_1
XFILLER_76_270 vssd1 vccd1 vssd1 vccd1 X2_sky130_ef_sc_hd__decap_40_12
XFILLER_64_421 vssd1 vccd1 vssd1 vccd1 X2_sky130_ef_sc_hd__decap_40_12
XFILLER_24_307 vccd1 vssd1 vccd1 vssd1 X2_sky130_fd_sc_hd__fill_1
XFILLER_64_465 vssd1 vccd1 vccd1 vssd1 X2_sky130_fd_sc_hd__fill_2
XFILLER_36_189 vssd1 vccd1 vccd1 vssd1 X2_sky130_fd_sc_hd__fill_4
XFILLER_91_273 vssd1 vccd1 vccd1 vssd1 X2_sky130_fd_sc_hd__fill_4
XFILLER_64_498 vssd1 vccd1 vccd1 vssd1 X2_sky130_fd_sc_hd__fill_2
XFILLER_51_137 vssd1 vccd1 vssd1 vccd1 X2_sky130_ef_sc_hd__decap_40_12
XFILLER_20_513 vssd1 vccd1 vssd1 vccd1 X2_sky130_ef_sc_hd__decap_40_12
XFILLER_20_557 vssd1 vccd1 vssd1 vccd1 X2_sky130_ef_sc_hd__decap_40_12
XTAP_TAPCELL_ROW_30_552 vccd1 vssd1 X2_sky130_fd_sc_hd__tapvpwrvgnd_1
XFILLER_10_27 vccd1 vssd1 vccd1 vssd1 X2_sky130_fd_sc_hd__fill_1
XFILLER_59_237 vssd1 vccd1 vssd1 vccd1 X2_sky130_ef_sc_hd__decap_40_12
XFILLER_87_557 vssd1 vccd1 vccd1 vssd1 X2_sky130_fd_sc_hd__fill_2
XFILLER_101_345 vccd1 vssd1 vccd1 vssd1 X2_sky130_fd_sc_hd__fill_1
XFILLER_101_356 vssd1 vccd1 vccd1 vssd1 X2_sky130_fd_sc_hd__fill_2
XFILLER_19_69 vssd1 vccd1 vssd1 vccd1 X2_sky130_ef_sc_hd__decap_40_12
XFILLER_28_613 vssd1 vccd1 vssd1 vccd1 X2_sky130_ef_sc_hd__decap_40_12
XFILLER_101_389 vssd1 vccd1 vccd1 vssd1 X2_sky130_fd_sc_hd__fill_2
XTAP_TAPCELL_ROW_2_244 vccd1 vssd1 X2_sky130_fd_sc_hd__tapvpwrvgnd_1
XFILLER_67_292 vssd1 vccd1 vccd1 vssd1 X2_sky130_fd_sc_hd__fill_2
XFILLER_67_281 vccd1 vssd1 vccd1 vssd1 X2_sky130_fd_sc_hd__fill_1
XFILLER_27_167 vccd1 vssd1 vccd1 vssd1 X2_sky130_fd_sc_hd__fill_1
XTAP_TAPCELL_ROW_38_641 vccd1 vssd1 X2_sky130_fd_sc_hd__tapvpwrvgnd_1
XFILLER_82_251 vccd1 vssd1 vccd1 vssd1 X2_sky130_fd_sc_hd__fill_1
XTAP_TAPCELL_ROW_66_950 vccd1 vssd1 X2_sky130_fd_sc_hd__tapvpwrvgnd_1
XFILLER_43_605 vssd1 vccd1 vccd1 vssd1 X2_sky130_fd_sc_hd__fill_2
XFILLER_15_329 vssd1 vccd1 vccd1 vssd1 X2_sky130_fd_sc_hd__fill_4
XFILLER_35_35 vssd1 vccd1 vssd1 vccd1 X2_sky130_ef_sc_hd__decap_40_12
XFILLER_35_57 vssd1 vccd1 vssd1 vccd1 X2_sky130_ef_sc_hd__decap_40_12
XFILLER_70_413 vssd1 vccd1 vccd1 vssd1 X2_sky130_fd_sc_hd__fill_4
XFILLER_70_457 vssd1 vccd1 vssd1 vccd1 X2_sky130_ef_sc_hd__decap_40_12
XFILLER_42_137 vssd1 vccd1 vccd1 vssd1 X2_sky130_fd_sc_hd__fill_2
XFILLER_23_373 vssd1 vccd1 vssd1 vccd1 X2_sky130_ef_sc_hd__decap_40_12
XANTENNA__605__CLK _606_/CLK vssd1 vccd1 vccd1 vssd1 X2_sky130_fd_sc_hd__diode_2
XFILLER_11_557 vssd1 vccd1 vccd1 vssd1 X2_sky130_fd_sc_hd__fill_2
XPHY_EDGE_ROW_14_Right_14 vccd1 vssd1 vccd1 vssd1 X2_sky130_fd_sc_hd__decap_3
XFILLER_7_517 vssd1 vccd1 vssd1 vccd1 X2_sky130_ef_sc_hd__decap_40_12
XFILLER_2_233 vssd1 vccd1 vssd1 vccd1 X2_sky130_ef_sc_hd__decap_40_12
XFILLER_2_277 vssd1 vccd1 vssd1 vccd1 X2_sky130_ef_sc_hd__decap_40_12
XPHY_EDGE_ROW_23_Right_23 vccd1 vssd1 vccd1 vssd1 X2_sky130_fd_sc_hd__decap_3
XFILLER_78_513 vssd1 vccd1 vssd1 vccd1 X2_sky130_ef_sc_hd__decap_40_12
XFILLER_93_505 vssd1 vccd1 vssd1 vccd1 X2_sky130_ef_sc_hd__decap_40_12
XFILLER_78_557 vssd1 vccd1 vssd1 vccd1 X2_sky130_ef_sc_hd__decap_40_12
XFILLER_19_613 vssd1 vccd1 vccd1 vssd1 X2_sky130_fd_sc_hd__fill_2
XFILLER_76_53 vssd1 vccd1 vssd1 vccd1 X2_sky130_ef_sc_hd__decap_40_12
XFILLER_76_97 vssd1 vccd1 vssd1 vccd1 X2_sky130_ef_sc_hd__decap_40_12
XFILLER_46_421 vssd1 vccd1 vssd1 vccd1 X2_sky130_ef_sc_hd__decap_40_12
XFILLER_34_605 vssd1 vccd1 vccd1 vssd1 X2_sky130_fd_sc_hd__fill_2
XFILLER_18_189 vssd1 vccd1 vccd1 vssd1 X2_sky130_fd_sc_hd__fill_4
XFILLER_92_41 vssd1 vccd1 vssd1 vccd1 X2_sky130_ef_sc_hd__decap_40_12
XFILLER_73_273 vssd1 vccd1 vccd1 vssd1 X2_sky130_fd_sc_hd__fill_4
XPHY_EDGE_ROW_32_Right_32 vccd1 vssd1 vccd1 vssd1 X2_sky130_fd_sc_hd__decap_3
XFILLER_33_137 vssd1 vccd1 vssd1 vccd1 X2_sky130_ef_sc_hd__decap_40_12
XFILLER_92_85 vssd1 vccd1 vssd1 vccd1 X2_sky130_ef_sc_hd__decap_40_12
X_407_ vccd1 vssd1 vccd1 vssd1 _425_/C _425_/B _355_/X _408_/B X2_sky130_fd_sc_hd__a21oi_1
XTAP_TAPCELL_ROW_44_699 vccd1 vssd1 X2_sky130_fd_sc_hd__tapvpwrvgnd_1
X_338_ vccd1 vssd1 vccd1 vssd1 _320_/X hold40/X _304_/A _338_/X hold49/X X2_sky130_fd_sc_hd__a22o_1
X_269_ vccd1 vssd1 vccd1 vssd1 _269_/B _320_/A _269_/A _310_/B X2_sky130_fd_sc_hd__or3_1
XANTENNA__460__A _473_/A vssd1 vccd1 vccd1 vssd1 X2_sky130_fd_sc_hd__diode_2
XFILLER_44_3 vssd1 vccd1 vssd1 vccd1 X2_sky130_ef_sc_hd__decap_40_12
XPHY_EDGE_ROW_41_Right_41 vccd1 vssd1 vccd1 vssd1 X2_sky130_fd_sc_hd__decap_3
XFILLER_69_557 vssd1 vccd1 vccd1 vssd1 X2_sky130_fd_sc_hd__fill_2
XFILLER_96_365 vccd1 vssd1 vccd1 vssd1 X2_sky130_fd_sc_hd__fill_1
XFILLER_96_398 vssd1 vccd1 vccd1 vssd1 X2_sky130_fd_sc_hd__fill_8
XFILLER_2_83 vccd1 vssd1 vccd1 vssd1 X2_sky130_fd_sc_hd__fill_1
XFILLER_37_443 vssd1 vccd1 vccd1 vssd1 X2_sky130_fd_sc_hd__fill_4
XFILLER_49_281 vssd1 vccd1 vssd1 vccd1 X2_sky130_ef_sc_hd__decap_40_12
XFILLER_64_251 vccd1 vssd1 vccd1 vssd1 X2_sky130_fd_sc_hd__fill_1
XFILLER_52_402 vssd1 vccd1 vssd1 vccd1 X2_sky130_ef_sc_hd__decap_40_12
XTAP_TAPCELL_ROW_35_600 vccd1 vssd1 X2_sky130_fd_sc_hd__tapvpwrvgnd_1
XPHY_EDGE_ROW_50_Right_50 vccd1 vssd1 vccd1 vssd1 X2_sky130_fd_sc_hd__decap_3
XFILLER_24_137 vssd1 vccd1 vccd1 vssd1 X2_sky130_fd_sc_hd__fill_2
XFILLER_40_619 vccd1 vssd1 vccd1 vssd1 X2_sky130_fd_sc_hd__fill_1
XFILLER_20_321 vssd1 vccd1 vssd1 vccd1 X2_sky130_ef_sc_hd__decap_40_12
XTAP_TAPCELL_ROW_15_390 vccd1 vssd1 X2_sky130_fd_sc_hd__tapvpwrvgnd_1
XFILLER_20_365 vssd1 vccd1 vssd1 vccd1 X2_sky130_ef_sc_hd__decap_40_12
XFILLER_21_15 vssd1 vccd1 vssd1 vccd1 X2_sky130_ef_sc_hd__decap_40_12
XTAP_TAPCELL_ROW_76_1056 vccd1 vssd1 X2_sky130_fd_sc_hd__tapvpwrvgnd_1
XFILLER_99_181 vssd1 vccd1 vssd1 vccd1 X2_sky130_ef_sc_hd__decap_40_12
XFILLER_101_153 vssd1 vccd1 vssd1 vccd1 X2_sky130_ef_sc_hd__decap_40_12
XFILLER_75_505 vssd1 vccd1 vssd1 vccd1 X2_sky130_ef_sc_hd__decap_40_12
XFILLER_28_421 vssd1 vccd1 vssd1 vccd1 X2_sky130_ef_sc_hd__decap_40_12
XFILLER_101_197 vssd1 vccd1 vccd1 vssd1 X2_sky130_fd_sc_hd__fill_2
XTAP_TAPCELL_ROW_87_1174 vccd1 vssd1 X2_sky130_fd_sc_hd__tapvpwrvgnd_1
XFILLER_55_273 vssd1 vccd1 vccd1 vssd1 X2_sky130_fd_sc_hd__fill_4
XFILLER_15_137 vssd1 vccd1 vssd1 vccd1 X2_sky130_ef_sc_hd__decap_40_12
XFILLER_70_221 vssd1 vccd1 vssd1 vccd1 X2_sky130_ef_sc_hd__decap_40_12
XFILLER_70_265 vssd1 vccd1 vssd1 vccd1 X2_sky130_ef_sc_hd__decap_40_12
XFILLER_23_181 vssd1 vccd1 vssd1 vccd1 X2_sky130_ef_sc_hd__decap_40_12
XFILLER_62_77 vssd1 vccd1 vccd1 vssd1 X2_sky130_fd_sc_hd__fill_4
XTAP_TAPCELL_ROW_41_669 vccd1 vssd1 X2_sky130_fd_sc_hd__tapvpwrvgnd_1
XFILLER_7_39 vssd1 vccd1 vssd1 vccd1 X2_sky130_ef_sc_hd__decap_40_12
XFILLER_3_553 vssd1 vccd1 vccd1 vssd1 X2_sky130_fd_sc_hd__fill_4
XFILLER_11_81 vssd1 vccd1 vssd1 vccd1 X2_sky130_ef_sc_hd__decap_40_12
XFILLER_3_597 vssd1 vccd1 vssd1 vccd1 X2_sky130_ef_sc_hd__decap_40_12
XFILLER_78_321 vssd1 vccd1 vssd1 vccd1 X2_sky130_ef_sc_hd__decap_40_12
XFILLER_78_365 vssd1 vccd1 vssd1 vccd1 X2_sky130_ef_sc_hd__decap_40_12
XFILLER_16_7 vssd1 vccd1 vssd1 vccd1 X2_sky130_ef_sc_hd__decap_40_12
XTAP_TAPCELL_ROW_49_758 vccd1 vssd1 X2_sky130_fd_sc_hd__tapvpwrvgnd_1
XFILLER_34_402 vssd1 vccd1 vssd1 vccd1 X2_sky130_ef_sc_hd__decap_40_12
XANTENNA__455__A _473_/A vssd1 vccd1 vccd1 vssd1 X2_sky130_fd_sc_hd__diode_2
Xinput31 vssd1 vccd1 wbs_dat_i[2] _297_/A0 vccd1 vssd1 X2_sky130_fd_sc_hd__clkbuf_2
Xinput20 vssd1 vccd1 _309_/C wbs_adr_i[6] vccd1 vssd1 X2_sky130_fd_sc_hd__buf_1
XFILLER_57_505 vssd1 vccd1 vssd1 vccd1 X2_sky130_ef_sc_hd__decap_40_12
XFILLER_96_195 vccd1 vssd1 vccd1 vssd1 X2_sky130_fd_sc_hd__fill_1
XFILLER_37_240 vssd1 vccd1 vccd1 vssd1 X2_sky130_fd_sc_hd__fill_4
XFILLER_37_251 vssd1 vccd1 vccd1 vssd1 X2_sky130_fd_sc_hd__fill_2
XFILLER_65_593 vccd1 vssd1 vccd1 vssd1 X2_sky130_fd_sc_hd__fill_1
XFILLER_65_571 vccd1 vssd1 vccd1 vssd1 X2_sky130_fd_sc_hd__fill_1
XFILLER_80_585 vssd1 vccd1 vccd1 vssd1 X2_sky130_fd_sc_hd__fill_2
XFILLER_52_265 vssd1 vccd1 vccd1 vssd1 X2_sky130_fd_sc_hd__fill_8
XFILLER_20_195 vccd1 vssd1 vccd1 vssd1 X2_sky130_fd_sc_hd__fill_1
XFILLER_0_501 vssd1 vccd1 vccd1 vssd1 X2_sky130_fd_sc_hd__fill_2
XFILLER_0_545 vssd1 vccd1 vssd1 vccd1 X2_sky130_ef_sc_hd__decap_40_12
XFILLER_0_589 vssd1 vccd1 vssd1 vccd1 X2_sky130_ef_sc_hd__decap_40_12
XTAP_TAPCELL_ROW_89_1203 vccd1 vssd1 X2_sky130_fd_sc_hd__tapvpwrvgnd_1
XFILLER_75_335 vccd1 vssd1 vccd1 vssd1 X2_sky130_fd_sc_hd__fill_1
XFILLER_57_55 vccd1 vssd1 vccd1 vssd1 X2_sky130_fd_sc_hd__fill_1
XFILLER_16_413 vssd1 vccd1 vccd1 vssd1 X2_sky130_fd_sc_hd__fill_4
XTAP_TAPCELL_ROW_18_419 vccd1 vssd1 X2_sky130_fd_sc_hd__tapvpwrvgnd_1
XFILLER_28_251 vccd1 vssd1 vccd1 vssd1 X2_sky130_fd_sc_hd__fill_1
XFILLER_90_338 vssd1 vccd1 vssd1 vccd1 X2_sky130_ef_sc_hd__decap_40_12
XTAP_TAPCELL_ROW_46_728 vccd1 vssd1 X2_sky130_fd_sc_hd__tapvpwrvgnd_1
XFILLER_16_457 vssd1 vccd1 vssd1 vccd1 X2_sky130_ef_sc_hd__decap_40_12
XFILLER_71_541 vssd1 vccd1 vssd1 vccd1 X2_sky130_ef_sc_hd__decap_40_12
XFILLER_31_405 vssd1 vccd1 vssd1 vccd1 X2_sky130_ef_sc_hd__decap_40_12
XFILLER_71_585 vssd1 vccd1 vssd1 vccd1 X2_sky130_ef_sc_hd__decap_40_12
XFILLER_31_449 vssd1 vccd1 vssd1 vccd1 X2_sky130_ef_sc_hd__decap_40_12
XFILLER_8_601 vssd1 vccd1 vssd1 vccd1 X2_sky130_ef_sc_hd__decap_40_12
XFILLER_7_111 vccd1 vssd1 vccd1 vssd1 X2_sky130_fd_sc_hd__fill_1
XFILLER_3_361 vssd1 vccd1 vssd1 vccd1 X2_sky130_ef_sc_hd__decap_40_12
XFILLER_98_416 vssd1 vccd1 vccd1 vssd1 X2_sky130_fd_sc_hd__fill_4
XFILLER_39_505 vssd1 vccd1 vssd1 vccd1 X2_sky130_ef_sc_hd__decap_40_12
XFILLER_39_527 vssd1 vccd1 vccd1 vssd1 X2_sky130_fd_sc_hd__fill_2
XFILLER_39_549 vssd1 vccd1 vccd1 vssd1 X2_sky130_fd_sc_hd__fill_8
XFILLER_78_195 vccd1 vssd1 vccd1 vssd1 X2_sky130_fd_sc_hd__fill_1
XFILLER_81_305 vssd1 vccd1 vssd1 vccd1 X2_sky130_ef_sc_hd__decap_40_12
XFILLER_66_357 vssd1 vccd1 vccd1 vssd1 X2_sky130_fd_sc_hd__fill_4
XFILLER_19_273 vssd1 vccd1 vccd1 vssd1 X2_sky130_fd_sc_hd__fill_4
XFILLER_93_165 vssd1 vccd1 vccd1 vssd1 X2_sky130_fd_sc_hd__fill_2
XFILLER_81_349 vssd1 vccd1 vssd1 vccd1 X2_sky130_ef_sc_hd__decap_40_12
XFILLER_34_265 vssd1 vccd1 vccd1 vssd1 X2_sky130_fd_sc_hd__fill_8
XFILLER_34_298 vccd1 vssd1 vccd1 vssd1 X2_sky130_fd_sc_hd__fill_1
XANTENNA__333__B1 _317_/C vssd1 vccd1 vccd1 vssd1 X2_sky130_fd_sc_hd__diode_2
XFILLER_89_405 vssd1 vccd1 vssd1 vccd1 X2_sky130_ef_sc_hd__decap_40_12
XPHY_EDGE_ROW_4_Right_4 vccd1 vssd1 vccd1 vssd1 X2_sky130_fd_sc_hd__decap_3
XTAP_TAPCELL_ROW_73_1026 vccd1 vssd1 X2_sky130_fd_sc_hd__tapvpwrvgnd_1
XFILLER_89_449 vssd1 vccd1 vssd1 vccd1 X2_sky130_ef_sc_hd__decap_40_12
XFILLER_84_121 vssd1 vccd1 vssd1 vccd1 X2_sky130_ef_sc_hd__decap_40_12
XFILLER_57_357 vssd1 vccd1 vssd1 vccd1 X2_sky130_ef_sc_hd__decap_40_12
XFILLER_27_69 vssd1 vccd1 vssd1 vccd1 X2_sky130_ef_sc_hd__decap_40_12
XFILLER_84_165 vssd1 vccd1 vssd1 vccd1 X2_sky130_ef_sc_hd__decap_40_12
XFILLER_72_305 vssd1 vccd1 vccd1 vssd1 X2_sky130_fd_sc_hd__fill_2
XFILLER_25_221 vssd1 vccd1 vccd1 vssd1 X2_sky130_fd_sc_hd__fill_2
XFILLER_38_593 vccd1 vssd1 vccd1 vssd1 X2_sky130_fd_sc_hd__fill_1
XFILLER_65_390 vssd1 vccd1 vccd1 vssd1 X2_sky130_fd_sc_hd__fill_2
XFILLER_53_541 vssd1 vccd1 vssd1 vccd1 X2_sky130_ef_sc_hd__decap_40_12
XFILLER_13_405 vssd1 vccd1 vssd1 vccd1 X2_sky130_ef_sc_hd__decap_40_12
XTAP_TAPCELL_ROW_84_1144 vccd1 vssd1 X2_sky130_fd_sc_hd__tapvpwrvgnd_1
XFILLER_53_585 vssd1 vccd1 vccd1 vssd1 X2_sky130_fd_sc_hd__fill_2
XFILLER_13_449 vssd1 vccd1 vssd1 vccd1 X2_sky130_ef_sc_hd__decap_40_12
XFILLER_43_57 vssd1 vccd1 vssd1 vccd1 X2_sky130_ef_sc_hd__decap_40_12
XTAP_TAPCELL_ROW_23_477 vccd1 vssd1 X2_sky130_fd_sc_hd__tapvpwrvgnd_1
XTAP_TAPCELL_ROW_51_786 vccd1 vssd1 X2_sky130_fd_sc_hd__tapvpwrvgnd_1
XFILLER_5_615 vccd1 vssd1 vccd1 vssd1 X2_sky130_fd_sc_hd__fill_1
XANTENNA__324__B1 _317_/C vssd1 vccd1 vccd1 vssd1 X2_sky130_fd_sc_hd__diode_2
XTAP_TAPCELL_ROW_95_1262 vccd1 vssd1 X2_sky130_fd_sc_hd__tapvpwrvgnd_1
XFILLER_4_29 vssd1 vccd1 vssd1 vccd1 X2_sky130_ef_sc_hd__decap_40_12
XFILLER_0_342 vssd1 vccd1 vccd1 vssd1 X2_sky130_fd_sc_hd__fill_4
XFILLER_68_65 vssd1 vccd1 vssd1 vccd1 X2_sky130_ef_sc_hd__decap_40_12
XANTENNA_input31_A wbs_dat_i[2] vssd1 vccd1 vccd1 vssd1 X2_sky130_fd_sc_hd__diode_2
XTAP_TAPCELL_ROW_59_864 vccd1 vssd1 X2_sky130_fd_sc_hd__tapvpwrvgnd_1
XFILLER_84_53 vssd1 vccd1 vssd1 vccd1 X2_sky130_ef_sc_hd__decap_40_12
XFILLER_75_165 vssd1 vccd1 vccd1 vssd1 X2_sky130_fd_sc_hd__fill_2
XFILLER_16_221 vssd1 vccd1 vssd1 vccd1 X2_sky130_ef_sc_hd__decap_40_12
XFILLER_84_97 vssd1 vccd1 vssd1 vccd1 X2_sky130_ef_sc_hd__decap_40_12
XFILLER_63_349 vssd1 vccd1 vssd1 vccd1 X2_sky130_ef_sc_hd__decap_40_12
XFILLER_16_265 vssd1 vccd1 vssd1 vccd1 X2_sky130_ef_sc_hd__decap_40_12
X_586_ vssd1 vccd1 vccd1 vssd1 _597_/CLK _586_/D _506_/Y _586_/Q X2_sky130_fd_sc_hd__dfrtp_1
XFILLER_44_574 vssd1 vccd1 vccd1 vssd1 X2_sky130_fd_sc_hd__fill_2
XFILLER_44_563 vssd1 vccd1 vccd1 vssd1 X2_sky130_fd_sc_hd__fill_8
XFILLER_71_393 vssd1 vccd1 vssd1 vccd1 X2_sky130_ef_sc_hd__decap_40_12
XFILLER_31_279 vccd1 vssd1 vccd1 vssd1 X2_sky130_fd_sc_hd__fill_1
XFILLER_8_475 vccd1 vssd1 vccd1 vssd1 X2_sky130_fd_sc_hd__fill_1
XFILLER_86_419 vccd1 vssd1 vccd1 vssd1 X2_sky130_fd_sc_hd__fill_1
XFILLER_39_335 vccd1 vssd1 vccd1 vssd1 X2_sky130_fd_sc_hd__fill_1
XFILLER_39_357 vssd1 vccd1 vccd1 vssd1 X2_sky130_fd_sc_hd__fill_2
XFILLER_66_121 vssd1 vccd1 vssd1 vccd1 X2_sky130_ef_sc_hd__decap_40_12
XFILLER_81_113 vssd1 vccd1 vssd1 vccd1 X2_sky130_ef_sc_hd__decap_40_12
XFILLER_66_165 vssd1 vccd1 vssd1 vccd1 X2_sky130_ef_sc_hd__decap_40_12
XFILLER_35_541 vssd1 vccd1 vccd1 vssd1 X2_sky130_fd_sc_hd__fill_4
XFILLER_50_533 vssd1 vccd1 vssd1 vccd1 X2_sky130_ef_sc_hd__decap_40_12
XFILLER_10_419 vccd1 vssd1 vccd1 vssd1 X2_sky130_fd_sc_hd__fill_1
XFILLER_13_27 vssd1 vccd1 vssd1 vccd1 X2_sky130_ef_sc_hd__decap_40_12
XTAP_TAPCELL_ROW_20_436 vccd1 vssd1 X2_sky130_fd_sc_hd__tapvpwrvgnd_1
XANTENNA__306__B1 _304_/X vssd1 vccd1 vccd1 vssd1 X2_sky130_fd_sc_hd__diode_2
XFILLER_89_279 vccd1 vssd1 vccd1 vssd1 X2_sky130_fd_sc_hd__fill_1
XFILLER_85_441 vssd1 vccd1 vccd1 vssd1 X2_sky130_fd_sc_hd__fill_4
XFILLER_73_603 vssd1 vccd1 vccd1 vssd1 X2_sky130_fd_sc_hd__fill_2
XFILLER_85_485 vssd1 vccd1 vssd1 vccd1 X2_sky130_ef_sc_hd__decap_40_12
XPHY_EDGE_ROW_79_Right_79 vccd1 vssd1 vccd1 vssd1 X2_sky130_fd_sc_hd__decap_3
XFILLER_57_165 vssd1 vccd1 vccd1 vssd1 X2_sky130_fd_sc_hd__fill_2
XTAP_TAPCELL_ROW_28_525 vccd1 vssd1 X2_sky130_fd_sc_hd__tapvpwrvgnd_1
XTAP_TAPCELL_ROW_56_834 vccd1 vssd1 X2_sky130_fd_sc_hd__tapvpwrvgnd_1
XFILLER_45_349 vssd1 vccd1 vssd1 vccd1 X2_sky130_ef_sc_hd__decap_40_12
XFILLER_60_319 vccd1 vssd1 vccd1 vssd1 X2_sky130_fd_sc_hd__fill_1
X_440_ vccd1 vssd1 vssd1 vccd1 _440_/B _440_/Y _440_/A X2_sky130_fd_sc_hd__nor2_2
XFILLER_41_500 vssd1 vccd1 vccd1 vssd1 X2_sky130_fd_sc_hd__fill_4
XFILLER_26_585 vssd1 vccd1 vccd1 vssd1 X2_sky130_fd_sc_hd__fill_2
XFILLER_53_393 vccd1 vssd1 vccd1 vssd1 X2_sky130_fd_sc_hd__fill_1
X_371_ _371_/X _546_/Q hold6/A vssd1 vccd1 vccd1 vssd1 X2_sky130_fd_sc_hd__and2b_1
XFILLER_9_217 vssd1 vccd1 vccd1 vssd1 X2_sky130_fd_sc_hd__fill_4
XFILLER_13_279 vccd1 vssd1 vccd1 vssd1 X2_sky130_fd_sc_hd__fill_1
XFILLER_41_588 vssd1 vccd1 vssd1 vccd1 X2_sky130_ef_sc_hd__decap_40_12
XFILLER_70_77 vssd1 vccd1 vccd1 vssd1 X2_sky130_fd_sc_hd__fill_4
XPHY_EDGE_ROW_88_Right_88 vccd1 vssd1 vccd1 vssd1 X2_sky130_fd_sc_hd__decap_3
XANTENNA__272__B _304_/A vssd1 vccd1 vccd1 vssd1 X2_sky130_fd_sc_hd__diode_2
XFILLER_5_445 vssd1 vccd1 vccd1 vssd1 X2_sky130_fd_sc_hd__fill_2
XFILLER_95_205 vssd1 vccd1 vssd1 vccd1 X2_sky130_ef_sc_hd__decap_40_12
XFILLER_68_419 vccd1 vssd1 vccd1 vssd1 X2_sky130_fd_sc_hd__fill_1
XANTENNA_input34_X _448_/A1 vssd1 vccd1 vccd1 vssd1 X2_sky130_fd_sc_hd__diode_2
XFILLER_49_611 vssd1 vccd1 vccd1 vssd1 X2_sky130_fd_sc_hd__fill_2
XFILLER_95_249 vssd1 vccd1 vssd1 vccd1 X2_sky130_ef_sc_hd__decap_40_12
XPHY_EDGE_ROW_97_Right_97 vccd1 vssd1 vccd1 vssd1 X2_sky130_fd_sc_hd__decap_3
XFILLER_48_121 vssd1 vccd1 vssd1 vccd1 X2_sky130_ef_sc_hd__decap_40_12
XFILLER_48_165 vssd1 vccd1 vssd1 vccd1 X2_sky130_ef_sc_hd__decap_40_12
XFILLER_63_113 vssd1 vccd1 vssd1 vccd1 X2_sky130_ef_sc_hd__decap_40_12
XFILLER_17_541 vssd1 vccd1 vssd1 vccd1 X2_sky130_ef_sc_hd__decap_40_12
XFILLER_17_585 vssd1 vccd1 vssd1 vccd1 X2_sky130_ef_sc_hd__decap_40_12
XFILLER_32_533 vssd1 vccd1 vssd1 vccd1 X2_sky130_ef_sc_hd__decap_40_12
XFILLER_32_555 vssd1 vccd1 vssd1 vccd1 X2_sky130_ef_sc_hd__decap_40_12
X_569_ vssd1 vccd1 vccd1 vssd1 _607_/CLK _569_/D _489_/Y _569_/Q X2_sky130_fd_sc_hd__dfrtp_1
XFILLER_74_3 vssd1 vccd1 vssd1 vccd1 X2_sky130_ef_sc_hd__decap_40_12
XFILLER_101_505 vssd1 vccd1 vssd1 vccd1 X2_sky130_ef_sc_hd__decap_40_12
XFILLER_86_249 vssd1 vccd1 vccd1 vssd1 X2_sky130_fd_sc_hd__fill_2
XFILLER_67_441 vssd1 vccd1 vccd1 vssd1 X2_sky130_fd_sc_hd__fill_4
XFILLER_27_305 vssd1 vccd1 vssd1 vccd1 X2_sky130_ef_sc_hd__decap_40_12
XFILLER_39_165 vssd1 vccd1 vccd1 vssd1 X2_sky130_fd_sc_hd__fill_2
XFILLER_67_485 vssd1 vccd1 vssd1 vccd1 X2_sky130_ef_sc_hd__decap_40_12
XFILLER_27_349 vssd1 vccd1 vssd1 vccd1 X2_sky130_ef_sc_hd__decap_40_12
XFILLER_82_433 vssd1 vccd1 vssd1 vccd1 X2_sky130_ef_sc_hd__decap_40_12
XFILLER_82_477 vssd1 vccd1 vssd1 vccd1 X2_sky130_ef_sc_hd__decap_40_12
XTAP_TAPCELL_ROW_53_804 vccd1 vssd1 X2_sky130_fd_sc_hd__tapvpwrvgnd_1
XFILLER_24_15 vssd1 vccd1 vssd1 vccd1 X2_sky130_ef_sc_hd__decap_40_12
XFILLER_35_360 vssd1 vccd1 vccd1 vssd1 X2_sky130_fd_sc_hd__fill_2
XTAP_TAPCELL_ROW_81_1114 vccd1 vssd1 X2_sky130_fd_sc_hd__tapvpwrvgnd_1
XFILLER_35_393 vssd1 vccd1 vssd1 vccd1 X2_sky130_ef_sc_hd__decap_40_12
XFILLER_10_249 vssd1 vccd1 vccd1 vssd1 X2_sky130_fd_sc_hd__fill_2
XTAP_TAPCELL_ROW_33_583 vccd1 vssd1 X2_sky130_fd_sc_hd__tapvpwrvgnd_1
XTAP_TAPCELL_ROW_61_892 vccd1 vssd1 X2_sky130_fd_sc_hd__tapvpwrvgnd_1
XFILLER_6_209 vssd1 vccd1 vssd1 vccd1 X2_sky130_ef_sc_hd__decap_40_12
XTAP_TAPCELL_ROW_79_1087 vccd1 vssd1 X2_sky130_fd_sc_hd__tapvpwrvgnd_1
XTAP_TAPCELL_ROW_92_1232 vccd1 vssd1 X2_sky130_fd_sc_hd__tapvpwrvgnd_1
XANTENNA_clkbuf_3_1__f_wb_clk_i_A clkbuf_0_wb_clk_i/X vssd1 vccd1 vccd1 vssd1 X2_sky130_fd_sc_hd__diode_2
XFILLER_77_205 vssd1 vccd1 vssd1 vccd1 X2_sky130_ef_sc_hd__decap_40_12
XFILLER_77_249 vssd1 vccd1 vssd1 vccd1 X2_sky130_ef_sc_hd__decap_40_12
XTAP_TAPCELL_ROW_5_275 vccd1 vssd1 X2_sky130_fd_sc_hd__tapvpwrvgnd_1
XFILLER_18_305 vssd1 vccd1 vccd1 vssd1 X2_sky130_fd_sc_hd__fill_2
XTAP_TAPCELL_ROW_69_981 vccd1 vssd1 X2_sky130_fd_sc_hd__tapvpwrvgnd_1
XFILLER_85_293 vssd1 vccd1 vssd1 vccd1 X2_sky130_ef_sc_hd__decap_40_12
XFILLER_65_55 vccd1 vssd1 vccd1 vssd1 X2_sky130_fd_sc_hd__fill_1
XFILLER_45_113 vssd1 vccd1 vssd1 vccd1 X2_sky130_ef_sc_hd__decap_40_12
XFILLER_61_617 vssd1 vccd1 vccd1 vssd1 X2_sky130_fd_sc_hd__fill_4
XFILLER_61_606 vccd1 vssd1 vccd1 vssd1 X2_sky130_fd_sc_hd__fill_1
X_423_ vssd1 vccd1 _420_/Y _423_/Y _422_/Y _425_/D _406_/B _416_/Y vccd1 vssd1 X2_sky130_fd_sc_hd__a41oi_1
XFILLER_14_533 vssd1 vccd1 vssd1 vccd1 X2_sky130_ef_sc_hd__decap_40_12
X_354_ _400_/B _538_/Q _553_/Q vssd1 vccd1 vccd1 vssd1 X2_sky130_fd_sc_hd__and2b_1
XFILLER_14_81 vssd1 vccd1 vccd1 vssd1 X2_sky130_fd_sc_hd__fill_2
X_285_ vssd1 vccd1 vccd1 vssd1 _594_/D hold75/X _289_/S _447_/A1 X2_sky130_fd_sc_hd__mux2_1
XFILLER_96_525 vssd1 vccd1 vccd1 vssd1 X2_sky130_fd_sc_hd__fill_4
XFILLER_96_569 vssd1 vccd1 vssd1 vccd1 X2_sky130_ef_sc_hd__decap_40_12
XFILLER_68_249 vssd1 vccd1 vccd1 vssd1 X2_sky130_fd_sc_hd__fill_2
Xinput7 vssd1 vccd1 _534_/D adc_data_in[4] vccd1 vssd1 X2_sky130_fd_sc_hd__buf_1
XFILLER_37_603 vssd1 vccd1 vccd1 vssd1 X2_sky130_fd_sc_hd__fill_2
XFILLER_37_614 vssd1 vccd1 vccd1 vssd1 X2_sky130_fd_sc_hd__fill_2
XFILLER_49_452 vssd1 vccd1 vccd1 vssd1 X2_sky130_fd_sc_hd__fill_4
XANTENNA__458__A _521_/A vssd1 vccd1 vccd1 vssd1 X2_sky130_fd_sc_hd__diode_2
XFILLER_76_282 vssd1 vccd1 vssd1 vccd1 X2_sky130_ef_sc_hd__decap_40_12
XFILLER_64_433 vssd1 vccd1 vssd1 vccd1 X2_sky130_ef_sc_hd__decap_40_12
XFILLER_64_477 vccd1 vssd1 vccd1 vssd1 X2_sky130_fd_sc_hd__fill_1
XFILLER_51_105 vssd1 vccd1 vccd1 vssd1 X2_sky130_fd_sc_hd__fill_4
XFILLER_17_393 vssd1 vccd1 vssd1 vccd1 X2_sky130_ef_sc_hd__decap_40_12
XFILLER_51_149 vssd1 vccd1 vssd1 vccd1 X2_sky130_ef_sc_hd__decap_40_12
XFILLER_20_525 vssd1 vccd1 vccd1 vssd1 X2_sky130_fd_sc_hd__fill_4
XFILLER_20_569 vssd1 vccd1 vssd1 vccd1 X2_sky130_ef_sc_hd__decap_40_12
XTAP_TAPCELL_ROW_30_553 vccd1 vssd1 X2_sky130_fd_sc_hd__tapvpwrvgnd_1
XFILLER_87_503 vccd1 vssd1 vccd1 vssd1 X2_sky130_fd_sc_hd__fill_1
XFILLER_59_205 vssd1 vccd1 vssd1 vccd1 X2_sky130_ef_sc_hd__decap_40_12
XFILLER_19_15 vssd1 vccd1 vssd1 vccd1 X2_sky130_ef_sc_hd__decap_40_12
XFILLER_101_335 vccd1 vssd1 vccd1 vssd1 X2_sky130_fd_sc_hd__fill_1
XFILLER_59_249 vssd1 vccd1 vssd1 vccd1 X2_sky130_ef_sc_hd__decap_40_12
XTAP_TAPCELL_ROW_2_245 vccd1 vssd1 X2_sky130_fd_sc_hd__tapvpwrvgnd_1
XFILLER_27_113 vssd1 vccd1 vssd1 vccd1 X2_sky130_ef_sc_hd__decap_40_12
XFILLER_55_433 vssd1 vccd1 vccd1 vssd1 X2_sky130_fd_sc_hd__fill_2
XTAP_TAPCELL_ROW_38_642 vccd1 vssd1 X2_sky130_fd_sc_hd__tapvpwrvgnd_1
XTAP_TAPCELL_ROW_66_951 vccd1 vssd1 X2_sky130_fd_sc_hd__tapvpwrvgnd_1
XFILLER_43_617 vssd1 vccd1 vccd1 vssd1 X2_sky130_fd_sc_hd__fill_2
XFILLER_35_47 vssd1 vccd1 vccd1 vssd1 X2_sky130_fd_sc_hd__fill_8
XFILLER_35_69 vssd1 vccd1 vssd1 vccd1 X2_sky130_ef_sc_hd__decap_40_12
XFILLER_70_469 vssd1 vccd1 vccd1 vssd1 X2_sky130_fd_sc_hd__fill_4
XFILLER_11_503 vccd1 vssd1 vccd1 vssd1 X2_sky130_fd_sc_hd__fill_1
XFILLER_23_385 vssd1 vccd1 vccd1 vssd1 X2_sky130_fd_sc_hd__fill_4
XFILLER_7_529 vssd1 vccd1 vssd1 vccd1 X2_sky130_ef_sc_hd__decap_40_12
XFILLER_51_57 vssd1 vccd1 vssd1 vccd1 X2_sky130_ef_sc_hd__decap_40_12
XFILLER_2_245 vssd1 vccd1 vccd1 vssd1 X2_sky130_fd_sc_hd__fill_4
XFILLER_4_3 vssd1 vccd1 vssd1 vccd1 X2_sky130_ef_sc_hd__decap_40_12
XFILLER_2_289 vssd1 vccd1 vssd1 vccd1 X2_sky130_ef_sc_hd__decap_40_12
XFILLER_78_525 vssd1 vccd1 vccd1 vssd1 X2_sky130_fd_sc_hd__fill_4
XFILLER_78_569 vssd1 vccd1 vssd1 vccd1 X2_sky130_ef_sc_hd__decap_40_12
XFILLER_93_517 vssd1 vccd1 vssd1 vccd1 X2_sky130_ef_sc_hd__decap_40_12
XFILLER_76_65 vssd1 vccd1 vssd1 vccd1 X2_sky130_ef_sc_hd__decap_40_12
XFILLER_46_400 vssd1 vccd1 vssd1 vccd1 X2_sky130_ef_sc_hd__decap_40_12
XFILLER_46_433 vssd1 vccd1 vssd1 vccd1 X2_sky130_ef_sc_hd__decap_40_12
XFILLER_46_477 vssd1 vccd1 vssd1 vccd1 X2_sky130_ef_sc_hd__decap_40_12
XFILLER_33_105 vssd1 vccd1 vccd1 vssd1 X2_sky130_fd_sc_hd__fill_4
XFILLER_92_53 vssd1 vccd1 vssd1 vccd1 X2_sky130_ef_sc_hd__decap_40_12
XPHY_EDGE_ROW_1_Left_103 vccd1 vssd1 vccd1 vssd1 X2_sky130_fd_sc_hd__decap_3
XFILLER_33_149 vssd1 vccd1 vssd1 vccd1 X2_sky130_ef_sc_hd__decap_40_12
XFILLER_92_97 vssd1 vccd1 vssd1 vccd1 X2_sky130_ef_sc_hd__decap_40_12
XFILLER_61_447 vccd1 vssd1 vccd1 vssd1 X2_sky130_fd_sc_hd__fill_1
XFILLER_14_363 vccd1 vssd1 vccd1 vssd1 X2_sky130_fd_sc_hd__fill_1
X_406_ vssd1 vccd1 _425_/C _406_/B _406_/A _406_/C vccd1 vssd1 X2_sky130_fd_sc_hd__and3_1
X_337_ vccd1 vssd1 vssd1 vccd1 _336_/X _317_/B hold57/X _335_/X _337_/X X2_sky130_fd_sc_hd__o22a_1
X_268_ _341_/B _320_/A _320_/C vssd1 vccd1 vccd1 vssd1 X2_sky130_fd_sc_hd__and2b_1
XPHY_EDGE_ROW_47_Left_149 vccd1 vssd1 vccd1 vssd1 X2_sky130_fd_sc_hd__decap_3
XFILLER_37_3 vssd1 vccd1 vssd1 vccd1 X2_sky130_ef_sc_hd__decap_40_12
XFILLER_69_503 vccd1 vssd1 vccd1 vssd1 X2_sky130_fd_sc_hd__fill_1
XFILLER_96_322 vssd1 vccd1 vccd1 vssd1 X2_sky130_fd_sc_hd__fill_2
XFILLER_49_293 vssd1 vccd1 vssd1 vccd1 X2_sky130_ef_sc_hd__decap_40_12
XANTENNA_clkbuf_3_0__f_wb_clk_i_X _553_/CLK vssd1 vccd1 vccd1 vssd1 X2_sky130_fd_sc_hd__diode_2
XFILLER_37_466 vccd1 vssd1 vccd1 vssd1 X2_sky130_fd_sc_hd__fill_1
XFILLER_25_617 vssd1 vccd1 vccd1 vssd1 X2_sky130_fd_sc_hd__fill_8
XTAP_TAPCELL_ROW_35_601 vccd1 vssd1 X2_sky130_fd_sc_hd__tapvpwrvgnd_1
XTAP_TAPCELL_ROW_63_910 vccd1 vssd1 X2_sky130_fd_sc_hd__tapvpwrvgnd_1
XPHY_EDGE_ROW_56_Left_158 vccd1 vssd1 vccd1 vssd1 X2_sky130_fd_sc_hd__decap_3
XFILLER_52_414 vssd1 vccd1 vccd1 vssd1 X2_sky130_fd_sc_hd__fill_4
XFILLER_52_469 vccd1 vssd1 vccd1 vssd1 X2_sky130_fd_sc_hd__fill_1
XTAP_TAPCELL_ROW_15_380 vccd1 vssd1 X2_sky130_fd_sc_hd__tapvpwrvgnd_1
XFILLER_20_333 vssd1 vccd1 vssd1 vccd1 X2_sky130_ef_sc_hd__decap_40_12
XFILLER_32_193 vssd1 vccd1 vccd1 vssd1 X2_sky130_fd_sc_hd__fill_2
XFILLER_20_377 vssd1 vccd1 vssd1 vccd1 X2_sky130_ef_sc_hd__decap_40_12
XFILLER_21_27 vssd1 vccd1 vssd1 vccd1 X2_sky130_ef_sc_hd__decap_40_12
XPHY_EDGE_ROW_65_Left_167 vccd1 vssd1 vccd1 vssd1 X2_sky130_fd_sc_hd__decap_3
XTAP_TAPCELL_ROW_76_1057 vccd1 vssd1 X2_sky130_fd_sc_hd__tapvpwrvgnd_1
XFILLER_99_193 vssd1 vccd1 vssd1 vccd1 X2_sky130_ef_sc_hd__decap_40_12
XFILLER_101_165 vssd1 vccd1 vccd1 vssd1 X2_sky130_fd_sc_hd__fill_2
XFILLER_75_517 vssd1 vccd1 vssd1 vccd1 X2_sky130_ef_sc_hd__decap_40_12
XFILLER_47_219 vssd1 vccd1 vccd1 vssd1 X2_sky130_fd_sc_hd__fill_4
XFILLER_28_433 vssd1 vccd1 vssd1 vccd1 X2_sky130_ef_sc_hd__decap_40_12
XFILLER_83_561 vssd1 vccd1 vssd1 vccd1 X2_sky130_ef_sc_hd__decap_40_12
XPHY_EDGE_ROW_74_Left_176 vccd1 vssd1 vccd1 vssd1 X2_sky130_fd_sc_hd__decap_3
XFILLER_15_105 vssd1 vccd1 vccd1 vssd1 X2_sky130_fd_sc_hd__fill_4
XFILLER_28_477 vssd1 vccd1 vssd1 vccd1 X2_sky130_ef_sc_hd__decap_40_12
XTAP_TAPCELL_ROW_87_1175 vccd1 vssd1 X2_sky130_fd_sc_hd__tapvpwrvgnd_1
XFILLER_55_285 vssd1 vccd1 vccd1 vssd1 X2_sky130_fd_sc_hd__fill_2
XFILLER_43_425 vssd1 vccd1 vccd1 vssd1 X2_sky130_fd_sc_hd__fill_2
XFILLER_15_149 vssd1 vccd1 vssd1 vccd1 X2_sky130_ef_sc_hd__decap_40_12
XFILLER_70_233 vssd1 vccd1 vssd1 vccd1 X2_sky130_ef_sc_hd__decap_40_12
XFILLER_55_296 vssd1 vccd1 vssd1 vccd1 X2_sky130_ef_sc_hd__decap_40_12
XFILLER_43_447 vccd1 vssd1 vccd1 vssd1 X2_sky130_fd_sc_hd__fill_1
XFILLER_70_277 vssd1 vccd1 vssd1 vccd1 X2_sky130_ef_sc_hd__decap_40_12
XFILLER_11_333 vssd1 vccd1 vccd1 vssd1 X2_sky130_fd_sc_hd__fill_2
XFILLER_23_193 vssd1 vccd1 vssd1 vccd1 X2_sky130_ef_sc_hd__decap_40_12
XFILLER_7_337 vssd1 vccd1 vssd1 vccd1 X2_sky130_ef_sc_hd__decap_40_12
XPHY_EDGE_ROW_83_Left_185 vccd1 vssd1 vccd1 vssd1 X2_sky130_fd_sc_hd__decap_3
XTAP_TAPCELL_ROW_98_1293 vccd1 vssd1 X2_sky130_fd_sc_hd__tapvpwrvgnd_1
XFILLER_11_93 vssd1 vccd1 vssd1 vccd1 X2_sky130_ef_sc_hd__decap_40_12
XFILLER_78_333 vssd1 vccd1 vssd1 vccd1 X2_sky130_ef_sc_hd__decap_40_12
XFILLER_78_377 vssd1 vccd1 vssd1 vccd1 X2_sky130_ef_sc_hd__decap_40_12
XPHY_EDGE_ROW_92_Left_194 vccd1 vssd1 vccd1 vssd1 X2_sky130_fd_sc_hd__decap_3
XTAP_TAPCELL_ROW_49_759 vccd1 vssd1 X2_sky130_fd_sc_hd__tapvpwrvgnd_1
XFILLER_34_414 vssd1 vccd1 vccd1 vssd1 X2_sky130_fd_sc_hd__fill_4
XFILLER_34_425 vssd1 vccd1 vccd1 vssd1 X2_sky130_fd_sc_hd__fill_2
XFILLER_14_193 vssd1 vccd1 vccd1 vssd1 X2_sky130_fd_sc_hd__fill_2
XTAP_TAPCELL_ROW_12_350 vccd1 vssd1 X2_sky130_fd_sc_hd__tapvpwrvgnd_1
Xinput21 vssd1 vccd1 _309_/B wbs_adr_i[7] vccd1 vssd1 X2_sky130_fd_sc_hd__buf_1
Xinput10 vssd1 vccd1 _537_/D adc_data_in[7] vccd1 vssd1 X2_sky130_fd_sc_hd__buf_1
Xinput32 vccd1 vssd1 vccd1 vssd1 _446_/A1 wbs_dat_i[3] X2_sky130_fd_sc_hd__dlymetal6s2s_1
XANTENNA__471__A _473_/A vssd1 vccd1 vccd1 vssd1 X2_sky130_fd_sc_hd__diode_2
XFILLER_89_609 vssd1 vccd1 vccd1 vssd1 X2_sky130_fd_sc_hd__fill_4
XFILLER_69_333 vssd1 vccd1 vccd1 vssd1 X2_sky130_fd_sc_hd__fill_2
XFILLER_96_141 vssd1 vccd1 vssd1 vccd1 X2_sky130_ef_sc_hd__decap_40_12
XFILLER_57_517 vssd1 vccd1 vssd1 vccd1 X2_sky130_ef_sc_hd__decap_40_12
XFILLER_65_561 vssd1 vccd1 vccd1 vssd1 X2_sky130_fd_sc_hd__fill_8
XFILLER_16_27 vccd1 vssd1 vccd1 vssd1 X2_sky130_fd_sc_hd__fill_1
XFILLER_25_447 vccd1 vssd1 vccd1 vssd1 X2_sky130_fd_sc_hd__fill_1
XFILLER_80_531 vccd1 vssd1 vccd1 vssd1 X2_sky130_fd_sc_hd__fill_1
XFILLER_52_244 vssd1 vccd1 vccd1 vssd1 X2_sky130_fd_sc_hd__fill_8
XFILLER_52_233 vssd1 vccd1 vccd1 vssd1 X2_sky130_fd_sc_hd__fill_4
XFILLER_13_609 vssd1 vccd1 vccd1 vssd1 X2_sky130_fd_sc_hd__fill_4
XFILLER_20_141 vssd1 vccd1 vssd1 vccd1 X2_sky130_ef_sc_hd__decap_40_12
XFILLER_32_15 vssd1 vccd1 vssd1 vccd1 X2_sky130_ef_sc_hd__decap_40_12
XFILLER_4_307 vccd1 vssd1 vccd1 vssd1 X2_sky130_fd_sc_hd__fill_1
XFILLER_0_524 vssd1 vccd1 vccd1 vssd1 X2_sky130_fd_sc_hd__fill_8
XFILLER_0_557 vssd1 vccd1 vccd1 vssd1 X2_sky130_fd_sc_hd__fill_2
XTAP_TAPCELL_ROW_89_1204 vccd1 vssd1 X2_sky130_fd_sc_hd__tapvpwrvgnd_1
XTAP_TAPCELL_ROW_46_729 vccd1 vssd1 X2_sky130_fd_sc_hd__tapvpwrvgnd_1
XFILLER_83_391 vccd1 vssd1 vccd1 vssd1 X2_sky130_fd_sc_hd__fill_1
XFILLER_73_55 vccd1 vssd1 vccd1 vssd1 X2_sky130_fd_sc_hd__fill_1
XFILLER_43_211 vssd1 vccd1 vssd1 vccd1 X2_sky130_ef_sc_hd__decap_40_12
XFILLER_16_469 vssd1 vccd1 vccd1 vssd1 X2_sky130_fd_sc_hd__fill_4
XFILLER_31_417 vssd1 vccd1 vssd1 vccd1 X2_sky130_ef_sc_hd__decap_40_12
XFILLER_71_553 vssd1 vccd1 vccd1 vssd1 X2_sky130_fd_sc_hd__fill_4
XFILLER_43_277 vssd1 vccd1 vccd1 vssd1 X2_sky130_fd_sc_hd__fill_2
XFILLER_71_597 vssd1 vccd1 vssd1 vccd1 X2_sky130_ef_sc_hd__decap_40_12
XFILLER_8_613 vssd1 vccd1 vssd1 vccd1 X2_sky130_ef_sc_hd__decap_40_12
XFILLER_7_167 vccd1 vssd1 vccd1 vssd1 X2_sky130_fd_sc_hd__fill_1
XFILLER_22_81 vssd1 vccd1 vccd1 vssd1 X2_sky130_fd_sc_hd__fill_2
XANTENNA__342__A1 hold5/X vssd1 vccd1 vccd1 vssd1 X2_sky130_fd_sc_hd__diode_2
XFILLER_98_41 vssd1 vccd1 vssd1 vccd1 X2_sky130_ef_sc_hd__decap_40_12
XFILLER_98_85 vssd1 vccd1 vssd1 vccd1 X2_sky130_ef_sc_hd__decap_40_12
XFILLER_98_439 vssd1 vccd1 vccd1 vssd1 X2_sky130_fd_sc_hd__fill_2
XFILLER_3_373 vssd1 vccd1 vssd1 vccd1 X2_sky130_ef_sc_hd__decap_40_12
XFILLER_39_517 vssd1 vccd1 vccd1 vssd1 X2_sky130_fd_sc_hd__fill_8
XFILLER_94_601 vssd1 vccd1 vssd1 vccd1 X2_sky130_ef_sc_hd__decap_40_12
XFILLER_78_141 vssd1 vccd1 vssd1 vccd1 X2_sky130_ef_sc_hd__decap_40_12
XFILLER_93_111 vccd1 vssd1 vccd1 vssd1 X2_sky130_fd_sc_hd__fill_1
XFILLER_81_317 vssd1 vccd1 vssd1 vccd1 X2_sky130_ef_sc_hd__decap_40_12
XFILLER_47_561 vssd1 vccd1 vssd1 vccd1 X2_sky130_ef_sc_hd__decap_40_12
XFILLER_62_531 vccd1 vssd1 vccd1 vssd1 X2_sky130_fd_sc_hd__fill_1
XFILLER_22_417 vssd1 vccd1 vccd1 vssd1 X2_sky130_fd_sc_hd__fill_2
XFILLER_8_83 vccd1 vssd1 vccd1 vssd1 X2_sky130_fd_sc_hd__fill_1
XFILLER_89_417 vssd1 vccd1 vssd1 vccd1 X2_sky130_ef_sc_hd__decap_40_12
XTAP_TAPCELL_ROW_73_1027 vccd1 vssd1 X2_sky130_fd_sc_hd__tapvpwrvgnd_1
XFILLER_97_461 vssd1 vccd1 vssd1 vccd1 X2_sky130_ef_sc_hd__decap_40_12
XFILLER_27_15 vssd1 vccd1 vssd1 vccd1 X2_sky130_ef_sc_hd__decap_40_12
XFILLER_84_133 vssd1 vccd1 vccd1 vssd1 X2_sky130_fd_sc_hd__fill_4
XFILLER_57_369 vssd1 vccd1 vssd1 vccd1 X2_sky130_ef_sc_hd__decap_40_12
XFILLER_45_509 vssd1 vccd1 vccd1 vssd1 X2_sky130_fd_sc_hd__fill_2
XFILLER_84_177 vssd1 vccd1 vssd1 vccd1 X2_sky130_ef_sc_hd__decap_40_12
XTAP_TAPCELL_ROW_84_1145 vccd1 vssd1 X2_sky130_fd_sc_hd__tapvpwrvgnd_1
XFILLER_80_361 vssd1 vccd1 vccd1 vssd1 X2_sky130_fd_sc_hd__fill_2
XFILLER_53_575 vccd1 vssd1 vccd1 vssd1 X2_sky130_fd_sc_hd__fill_1
XFILLER_13_417 vssd1 vccd1 vssd1 vccd1 X2_sky130_ef_sc_hd__decap_40_12
XFILLER_25_277 vssd1 vccd1 vccd1 vssd1 X2_sky130_fd_sc_hd__fill_2
XFILLER_43_69 vssd1 vccd1 vssd1 vccd1 X2_sky130_ef_sc_hd__decap_40_12
XFILLER_21_461 vssd1 vccd1 vssd1 vccd1 X2_sky130_ef_sc_hd__decap_40_12
XTAP_TAPCELL_ROW_23_478 vccd1 vssd1 X2_sky130_fd_sc_hd__tapvpwrvgnd_1
XTAP_TAPCELL_ROW_51_776 vccd1 vssd1 X2_sky130_fd_sc_hd__tapvpwrvgnd_1
XFILLER_4_137 vssd1 vccd1 vccd1 vssd1 X2_sky130_fd_sc_hd__fill_2
XTAP_TAPCELL_ROW_95_1263 vccd1 vssd1 X2_sky130_fd_sc_hd__tapvpwrvgnd_1
XFILLER_76_601 vssd1 vccd1 vssd1 vccd1 X2_sky130_ef_sc_hd__decap_40_12
XFILLER_68_77 vssd1 vccd1 vccd1 vssd1 X2_sky130_fd_sc_hd__fill_4
XFILLER_0_365 vssd1 vccd1 vssd1 vccd1 X2_sky130_ef_sc_hd__decap_40_12
XFILLER_75_111 vccd1 vssd1 vccd1 vssd1 X2_sky130_fd_sc_hd__fill_1
XANTENNA_input24_A wbs_dat_i[10] vssd1 vccd1 vccd1 vssd1 X2_sky130_fd_sc_hd__diode_2
XTAP_TAPCELL_ROW_59_865 vccd1 vssd1 X2_sky130_fd_sc_hd__tapvpwrvgnd_1
XFILLER_29_561 vssd1 vccd1 vssd1 vccd1 X2_sky130_ef_sc_hd__decap_40_12
XFILLER_91_615 vccd1 vssd1 vccd1 vssd1 X2_sky130_fd_sc_hd__fill_1
XFILLER_84_65 vssd1 vccd1 vssd1 vccd1 X2_sky130_ef_sc_hd__decap_40_12
XFILLER_16_233 vssd1 vccd1 vssd1 vccd1 X2_sky130_ef_sc_hd__decap_40_12
XFILLER_44_531 vccd1 vssd1 vccd1 vssd1 X2_sky130_fd_sc_hd__fill_1
XFILLER_17_81 vssd1 vccd1 vssd1 vccd1 X2_sky130_ef_sc_hd__decap_40_12
X_585_ vssd1 vccd1 vccd1 vssd1 _609_/CLK _585_/D _505_/Y _585_/Q X2_sky130_fd_sc_hd__dfrtp_1
XFILLER_71_361 vssd1 vccd1 vssd1 vccd1 X2_sky130_ef_sc_hd__decap_40_12
XFILLER_16_277 vssd1 vccd1 vssd1 vccd1 X2_sky130_ef_sc_hd__decap_40_12
XFILLER_31_225 vssd1 vccd1 vssd1 vccd1 X2_sky130_ef_sc_hd__decap_40_12
XFILLER_8_421 vssd1 vccd1 vssd1 vccd1 X2_sky130_ef_sc_hd__decap_40_12
XFILLER_3_181 vssd1 vccd1 vssd1 vccd1 X2_sky130_ef_sc_hd__decap_40_12
XANTENNA__590__CLK _606_/CLK vssd1 vccd1 vccd1 vssd1 X2_sky130_fd_sc_hd__diode_2
XFILLER_79_461 vssd1 vccd1 vssd1 vccd1 X2_sky130_ef_sc_hd__decap_40_12
XFILLER_67_612 vssd1 vccd1 vccd1 vssd1 X2_sky130_fd_sc_hd__fill_4
XFILLER_66_133 vssd1 vccd1 vccd1 vssd1 X2_sky130_fd_sc_hd__fill_4
XFILLER_94_475 vccd1 vssd1 vccd1 vssd1 X2_sky130_fd_sc_hd__fill_1
XFILLER_66_177 vssd1 vccd1 vssd1 vccd1 X2_sky130_ef_sc_hd__decap_40_12
XFILLER_81_125 vssd1 vccd1 vssd1 vccd1 X2_sky130_ef_sc_hd__decap_40_12
XFILLER_35_564 vssd1 vccd1 vccd1 vssd1 X2_sky130_fd_sc_hd__fill_2
XFILLER_81_169 vssd1 vccd1 vssd1 vccd1 X2_sky130_ef_sc_hd__decap_40_12
XFILLER_62_361 vssd1 vccd1 vccd1 vssd1 X2_sky130_fd_sc_hd__fill_2
XFILLER_50_545 vssd1 vccd1 vssd1 vccd1 X2_sky130_ef_sc_hd__decap_40_12
XFILLER_13_39 vssd1 vccd1 vssd1 vccd1 X2_sky130_ef_sc_hd__decap_40_12
XFILLER_50_589 vccd1 vssd1 vccd1 vssd1 X2_sky130_fd_sc_hd__fill_1
XTAP_TAPCELL_ROW_20_437 vccd1 vssd1 X2_sky130_fd_sc_hd__tapvpwrvgnd_1
XFILLER_89_225 vssd1 vccd1 vssd1 vccd1 X2_sky130_ef_sc_hd__decap_40_12
XFILLER_58_601 vssd1 vccd1 vccd1 vssd1 X2_sky130_fd_sc_hd__fill_2
XFILLER_57_111 vccd1 vssd1 vccd1 vssd1 X2_sky130_fd_sc_hd__fill_1
XFILLER_73_615 vccd1 vssd1 vccd1 vssd1 X2_sky130_fd_sc_hd__fill_1
XFILLER_26_531 vccd1 vssd1 vccd1 vssd1 X2_sky130_fd_sc_hd__fill_1
XTAP_TAPCELL_ROW_28_526 vccd1 vssd1 X2_sky130_fd_sc_hd__tapvpwrvgnd_1
XFILLER_85_497 vssd1 vccd1 vccd1 vssd1 X2_sky130_fd_sc_hd__fill_4
XTAP_TAPCELL_ROW_56_835 vccd1 vssd1 X2_sky130_fd_sc_hd__tapvpwrvgnd_1
XFILLER_45_328 vssd1 vccd1 vccd1 vssd1 X2_sky130_fd_sc_hd__fill_8
XFILLER_60_309 vssd1 vccd1 vccd1 vssd1 X2_sky130_fd_sc_hd__fill_8
XFILLER_13_225 vssd1 vccd1 vssd1 vccd1 X2_sky130_ef_sc_hd__decap_40_12
X_370_ vccd1 vssd1 vssd1 vccd1 hold6/A _546_/Q _373_/C X2_sky130_fd_sc_hd__nand2b_1
XFILLER_95_217 vssd1 vccd1 vccd1 vssd1 X2_sky130_fd_sc_hd__fill_4
XFILLER_0_195 vccd1 vssd1 vccd1 vssd1 X2_sky130_fd_sc_hd__fill_1
XFILLER_48_133 vssd1 vccd1 vccd1 vssd1 X2_sky130_fd_sc_hd__fill_4
XFILLER_76_475 vccd1 vssd1 vccd1 vssd1 X2_sky130_fd_sc_hd__fill_1
XFILLER_48_177 vssd1 vccd1 vssd1 vccd1 X2_sky130_ef_sc_hd__decap_40_12
XFILLER_29_391 vccd1 vssd1 vccd1 vssd1 X2_sky130_fd_sc_hd__fill_1
XFILLER_91_445 vssd1 vccd1 vccd1 vssd1 X2_sky130_fd_sc_hd__fill_2
XFILLER_63_125 vssd1 vccd1 vssd1 vccd1 X2_sky130_ef_sc_hd__decap_40_12
XFILLER_17_553 vssd1 vccd1 vccd1 vssd1 X2_sky130_fd_sc_hd__fill_4
XFILLER_63_169 vssd1 vccd1 vssd1 vccd1 X2_sky130_ef_sc_hd__decap_40_12
XFILLER_17_597 vssd1 vccd1 vssd1 vccd1 X2_sky130_ef_sc_hd__decap_40_12
XFILLER_32_501 vssd1 vccd1 vccd1 vssd1 X2_sky130_fd_sc_hd__fill_2
X_568_ vssd1 vccd1 vccd1 vssd1 _599_/CLK _568_/D _488_/Y _568_/Q X2_sky130_fd_sc_hd__dfrtp_1
XFILLER_44_361 vssd1 vccd1 vccd1 vssd1 X2_sky130_fd_sc_hd__fill_2
XFILLER_32_545 vssd1 vccd1 vccd1 vssd1 X2_sky130_fd_sc_hd__fill_2
XFILLER_32_567 vssd1 vccd1 vssd1 vccd1 X2_sky130_ef_sc_hd__decap_40_12
XFILLER_32_589 vccd1 vssd1 vccd1 vssd1 X2_sky130_fd_sc_hd__fill_1
X_499_ vccd1 vssd1 vccd1 vssd1 _499_/Y _527_/A X2_sky130_fd_sc_hd__inv_2
XFILLER_8_251 vccd1 vssd1 vccd1 vssd1 X2_sky130_fd_sc_hd__fill_1
XFILLER_67_3 vccd1 vssd1 vccd1 vssd1 X2_sky130_fd_sc_hd__fill_1
XFILLER_99_501 vssd1 vccd1 vccd1 vssd1 X2_sky130_fd_sc_hd__fill_2
XFILLER_5_51 vssd1 vccd1 vccd1 vssd1 X2_sky130_fd_sc_hd__fill_4
XFILLER_101_517 vssd1 vccd1 vssd1 vccd1 X2_sky130_ef_sc_hd__decap_40_12
XFILLER_39_111 vccd1 vssd1 vccd1 vssd1 X2_sky130_fd_sc_hd__fill_1
XFILLER_27_317 vssd1 vccd1 vssd1 vccd1 X2_sky130_ef_sc_hd__decap_40_12
XFILLER_82_401 vssd1 vccd1 vssd1 vccd1 X2_sky130_ef_sc_hd__decap_40_12
XFILLER_55_615 vccd1 vssd1 vccd1 vssd1 X2_sky130_fd_sc_hd__fill_1
XFILLER_82_445 vssd1 vccd1 vssd1 vccd1 X2_sky130_ef_sc_hd__decap_40_12
XFILLER_67_497 vssd1 vccd1 vccd1 vssd1 X2_sky130_fd_sc_hd__fill_4
XTAP_TAPCELL_ROW_53_805 vccd1 vssd1 X2_sky130_fd_sc_hd__tapvpwrvgnd_1
XFILLER_42_309 vssd1 vccd1 vccd1 vssd1 X2_sky130_fd_sc_hd__fill_4
XFILLER_23_501 vssd1 vccd1 vccd1 vssd1 X2_sky130_fd_sc_hd__fill_2
XFILLER_35_372 vssd1 vccd1 vccd1 vssd1 X2_sky130_fd_sc_hd__fill_2
XFILLER_82_489 vssd1 vccd1 vssd1 vccd1 X2_sky130_ef_sc_hd__decap_40_12
XTAP_TAPCELL_ROW_81_1115 vccd1 vssd1 X2_sky130_fd_sc_hd__tapvpwrvgnd_1
XFILLER_24_27 vccd1 vssd1 vccd1 vssd1 X2_sky130_fd_sc_hd__fill_1
XTAP_TAPCELL_ROW_33_584 vccd1 vssd1 X2_sky130_fd_sc_hd__tapvpwrvgnd_1
XTAP_TAPCELL_ROW_61_893 vccd1 vssd1 X2_sky130_fd_sc_hd__tapvpwrvgnd_1
XFILLER_40_15 vssd1 vccd1 vssd1 vccd1 X2_sky130_ef_sc_hd__decap_40_12
XTAP_TAPCELL_ROW_79_1088 vccd1 vssd1 X2_sky130_fd_sc_hd__tapvpwrvgnd_1
XTAP_TAPCELL_ROW_92_1233 vccd1 vssd1 X2_sky130_fd_sc_hd__tapvpwrvgnd_1
XFILLER_77_217 vssd1 vccd1 vccd1 vssd1 X2_sky130_fd_sc_hd__fill_4
XFILLER_49_57 vssd1 vccd1 vssd1 vccd1 X2_sky130_ef_sc_hd__decap_40_12
XTAP_TAPCELL_ROW_5_276 vccd1 vssd1 X2_sky130_fd_sc_hd__tapvpwrvgnd_1
XFILLER_92_209 vssd1 vccd1 vssd1 vccd1 X2_sky130_ef_sc_hd__decap_40_12
XFILLER_85_261 vssd1 vccd1 vssd1 vccd1 X2_sky130_ef_sc_hd__decap_40_12
XTAP_TAPCELL_ROW_69_982 vccd1 vssd1 X2_sky130_fd_sc_hd__tapvpwrvgnd_1
XFILLER_58_475 vccd1 vssd1 vccd1 vssd1 X2_sky130_fd_sc_hd__fill_1
XFILLER_73_445 vssd1 vccd1 vccd1 vssd1 X2_sky130_fd_sc_hd__fill_2
XFILLER_45_125 vssd1 vccd1 vssd1 vccd1 X2_sky130_ef_sc_hd__decap_40_12
XFILLER_45_169 vssd1 vccd1 vssd1 vccd1 X2_sky130_ef_sc_hd__decap_40_12
XFILLER_14_501 vssd1 vccd1 vssd1 vccd1 X2_sky130_ef_sc_hd__decap_40_12
XFILLER_26_361 vssd1 vccd1 vccd1 vssd1 X2_sky130_fd_sc_hd__fill_2
X_422_ vccd1 vssd1 vssd1 vccd1 _422_/A _422_/B _422_/Y X2_sky130_fd_sc_hd__nor2_1
XFILLER_14_545 vssd1 vccd1 vssd1 vccd1 X2_sky130_ef_sc_hd__decap_40_12
XFILLER_60_139 vccd1 vssd1 vccd1 vssd1 X2_sky130_fd_sc_hd__fill_1
XFILLER_14_589 vssd1 vccd1 vssd1 vccd1 X2_sky130_ef_sc_hd__decap_40_12
XTAP_TAPCELL_ROW_101_1340 vccd1 vssd1 X2_sky130_fd_sc_hd__tapvpwrvgnd_1
XFILLER_81_55 vccd1 vssd1 vccd1 vssd1 X2_sky130_fd_sc_hd__fill_1
X_353_ vccd1 vssd1 vssd1 vccd1 _406_/A _400_/A _406_/B X2_sky130_fd_sc_hd__nand2_1
X_284_ vssd1 vccd1 vccd1 vssd1 _595_/D hold42/X _289_/S _448_/A1 X2_sky130_fd_sc_hd__mux2_1
XFILLER_5_221 vssd1 vccd1 vccd1 vssd1 X2_sky130_fd_sc_hd__fill_2
XFILLER_30_81 vssd1 vccd1 vccd1 vssd1 X2_sky130_fd_sc_hd__fill_2
XFILLER_39_7 vssd1 vccd1 vccd1 vssd1 X2_sky130_fd_sc_hd__fill_2
Xinput8 vssd1 vccd1 _535_/D adc_data_in[5] vccd1 vssd1 X2_sky130_fd_sc_hd__buf_1
XFILLER_76_294 vssd1 vccd1 vssd1 vccd1 X2_sky130_ef_sc_hd__decap_40_12
XANTENNA_max_cap59_X _317_/C vssd1 vccd1 vccd1 vssd1 X2_sky130_fd_sc_hd__diode_2
XFILLER_24_309 vssd1 vccd1 vssd1 vccd1 X2_sky130_ef_sc_hd__decap_40_12
XFILLER_64_467 vccd1 vssd1 vccd1 vssd1 X2_sky130_fd_sc_hd__fill_1
XFILLER_64_445 vssd1 vccd1 vssd1 vccd1 X2_sky130_ef_sc_hd__decap_40_12
XFILLER_17_361 vssd1 vccd1 vssd1 vccd1 X2_sky130_ef_sc_hd__decap_40_12
XANTENNA__474__A _521_/A vssd1 vccd1 vccd1 vssd1 X2_sky130_fd_sc_hd__diode_2
XTAP_TAPCELL_ROW_30_554 vccd1 vssd1 X2_sky130_fd_sc_hd__tapvpwrvgnd_1
XFILLER_10_29 vssd1 vccd1 vssd1 vccd1 X2_sky130_ef_sc_hd__decap_40_12
XFILLER_101_314 vssd1 vccd1 vccd1 vssd1 X2_sky130_fd_sc_hd__fill_4
XFILLER_59_217 vssd1 vccd1 vccd1 vssd1 X2_sky130_fd_sc_hd__fill_4
XFILLER_19_27 vssd1 vccd1 vssd1 vccd1 X2_sky130_ef_sc_hd__decap_40_12
XFILLER_87_559 vccd1 vssd1 vccd1 vssd1 X2_sky130_fd_sc_hd__fill_1
XFILLER_101_369 vccd1 vssd1 vccd1 vssd1 X2_sky130_fd_sc_hd__fill_1
XFILLER_74_209 vssd1 vccd1 vssd1 vccd1 X2_sky130_ef_sc_hd__decap_40_12
XFILLER_67_261 vssd1 vccd1 vssd1 vccd1 X2_sky130_ef_sc_hd__decap_40_12
XTAP_TAPCELL_ROW_2_246 vccd1 vssd1 X2_sky130_fd_sc_hd__tapvpwrvgnd_1
XFILLER_27_125 vssd1 vccd1 vssd1 vccd1 X2_sky130_ef_sc_hd__decap_40_12
XTAP_TAPCELL_ROW_38_643 vccd1 vssd1 X2_sky130_fd_sc_hd__tapvpwrvgnd_1
XFILLER_82_253 vssd1 vccd1 vssd1 vccd1 X2_sky130_ef_sc_hd__decap_40_12
XTAP_TAPCELL_ROW_66_941 vccd1 vssd1 X2_sky130_fd_sc_hd__tapvpwrvgnd_1
XFILLER_55_445 vssd1 vccd1 vccd1 vssd1 X2_sky130_fd_sc_hd__fill_2
XFILLER_27_169 vssd1 vccd1 vssd1 vccd1 X2_sky130_ef_sc_hd__decap_40_12
XFILLER_42_139 vccd1 vssd1 vccd1 vssd1 X2_sky130_fd_sc_hd__fill_1
XFILLER_11_559 vccd1 vssd1 vccd1 vssd1 X2_sky130_fd_sc_hd__fill_1
XFILLER_51_69 vssd1 vccd1 vssd1 vccd1 X2_sky130_ef_sc_hd__decap_40_12
XFILLER_19_615 vccd1 vssd1 vccd1 vssd1 X2_sky130_fd_sc_hd__fill_1
XFILLER_93_529 vssd1 vccd1 vssd1 vccd1 X2_sky130_ef_sc_hd__decap_40_12
XFILLER_86_581 vssd1 vccd1 vccd1 vssd1 X2_sky130_fd_sc_hd__fill_4
XFILLER_76_77 vssd1 vccd1 vccd1 vssd1 X2_sky130_fd_sc_hd__fill_4
XFILLER_58_261 vssd1 vccd1 vccd1 vssd1 X2_sky130_fd_sc_hd__fill_2
XFILLER_46_412 vssd1 vccd1 vccd1 vssd1 X2_sky130_fd_sc_hd__fill_8
XFILLER_46_445 vssd1 vccd1 vssd1 vccd1 X2_sky130_ef_sc_hd__decap_40_12
XFILLER_46_489 vssd1 vccd1 vssd1 vccd1 X2_sky130_ef_sc_hd__decap_40_12
XFILLER_92_65 vssd1 vccd1 vssd1 vccd1 X2_sky130_ef_sc_hd__decap_40_12
XFILLER_25_81 vssd1 vccd1 vssd1 vccd1 X2_sky130_ef_sc_hd__decap_40_12
X_405_ vccd1 vssd1 vssd1 vccd1 _408_/A _405_/A _422_/B X2_sky130_fd_sc_hd__or2_1
XFILLER_41_161 vssd1 vccd1 vccd1 vssd1 X2_sky130_fd_sc_hd__fill_4
X_336_ vccd1 vssd1 vccd1 vssd1 _320_/X hold32/X _304_/A _336_/X hold53/X X2_sky130_fd_sc_hd__a22o_1
XFILLER_10_581 vssd1 vccd1 vccd1 vssd1 X2_sky130_fd_sc_hd__fill_4
X_267_ vccd1 vssd1 vssd1 vccd1 _269_/A _269_/B _320_/C X2_sky130_fd_sc_hd__nor2_1
XFILLER_6_585 vssd1 vccd1 vccd1 vssd1 X2_sky130_fd_sc_hd__fill_2
XANTENNA_hold5_X hold5/X vssd1 vccd1 vccd1 vssd1 X2_sky130_fd_sc_hd__diode_2
XFILLER_69_559 vccd1 vssd1 vccd1 vssd1 X2_sky130_fd_sc_hd__fill_1
XFILLER_2_41 vssd1 vccd1 vssd1 vccd1 X2_sky130_ef_sc_hd__decap_40_12
XFILLER_84_529 vssd1 vccd1 vccd1 vssd1 X2_sky130_fd_sc_hd__fill_2
XFILLER_56_209 vssd1 vccd1 vssd1 vccd1 X2_sky130_ef_sc_hd__decap_40_12
XFILLER_2_85 vssd1 vccd1 vssd1 vccd1 X2_sky130_ef_sc_hd__decap_40_12
XFILLER_49_261 vssd1 vccd1 vssd1 vccd1 X2_sky130_ef_sc_hd__decap_40_12
XTAP_TAPCELL_ROW_35_602 vccd1 vssd1 X2_sky130_fd_sc_hd__tapvpwrvgnd_1
XFILLER_37_489 vssd1 vccd1 vccd1 vssd1 X2_sky130_fd_sc_hd__fill_2
XFILLER_64_253 vssd1 vccd1 vssd1 vccd1 X2_sky130_ef_sc_hd__decap_40_12
XTAP_TAPCELL_ROW_63_911 vccd1 vssd1 X2_sky130_fd_sc_hd__tapvpwrvgnd_1
XFILLER_52_426 vssd1 vccd1 vccd1 vssd1 X2_sky130_fd_sc_hd__fill_2
XFILLER_24_139 vccd1 vssd1 vccd1 vssd1 X2_sky130_fd_sc_hd__fill_1
XFILLER_52_437 vssd1 vccd1 vccd1 vssd1 X2_sky130_fd_sc_hd__fill_2
XFILLER_20_301 vssd1 vccd1 vccd1 vssd1 X2_sky130_fd_sc_hd__fill_4
XTAP_TAPCELL_ROW_15_381 vccd1 vssd1 X2_sky130_fd_sc_hd__tapvpwrvgnd_1
XFILLER_20_345 vssd1 vccd1 vssd1 vccd1 X2_sky130_ef_sc_hd__decap_40_12
XTAP_TAPCELL_ROW_43_690 vccd1 vssd1 X2_sky130_fd_sc_hd__tapvpwrvgnd_1
XFILLER_20_389 vssd1 vccd1 vssd1 vccd1 X2_sky130_ef_sc_hd__decap_40_12
XFILLER_21_39 vssd1 vccd1 vssd1 vccd1 X2_sky130_ef_sc_hd__decap_40_12
XTAP_TAPCELL_ROW_76_1058 vccd1 vssd1 X2_sky130_fd_sc_hd__tapvpwrvgnd_1
XFILLER_99_161 vssd1 vccd1 vccd1 vssd1 X2_sky130_fd_sc_hd__fill_4
XFILLER_101_111 vccd1 vssd1 vccd1 vssd1 X2_sky130_fd_sc_hd__fill_1
XFILLER_28_401 vssd1 vccd1 vssd1 vccd1 X2_sky130_ef_sc_hd__decap_40_12
XFILLER_75_529 vssd1 vccd1 vssd1 vccd1 X2_sky130_ef_sc_hd__decap_40_12
XFILLER_68_592 vssd1 vccd1 vccd1 vssd1 X2_sky130_fd_sc_hd__fill_4
XFILLER_28_445 vssd1 vccd1 vssd1 vccd1 X2_sky130_ef_sc_hd__decap_40_12
XFILLER_28_489 vssd1 vccd1 vssd1 vccd1 X2_sky130_ef_sc_hd__decap_40_12
XTAP_TAPCELL_ROW_87_1176 vccd1 vssd1 X2_sky130_fd_sc_hd__tapvpwrvgnd_1
XFILLER_83_573 vssd1 vccd1 vssd1 vccd1 X2_sky130_ef_sc_hd__decap_40_12
Xmax_cap59 vssd1 vccd1 _310_/Y _317_/C vccd1 vssd1 X2_sky130_fd_sc_hd__clkbuf_4
XFILLER_70_245 vssd1 vccd1 vccd1 vssd1 X2_sky130_fd_sc_hd__fill_4
XFILLER_30_109 vssd1 vccd1 vssd1 vccd1 X2_sky130_ef_sc_hd__decap_40_12
XFILLER_23_161 vssd1 vccd1 vccd1 vssd1 X2_sky130_fd_sc_hd__fill_4
XFILLER_70_289 vssd1 vccd1 vssd1 vccd1 X2_sky130_ef_sc_hd__decap_40_12
XFILLER_51_492 vssd1 vccd1 vssd1 vccd1 X2_sky130_ef_sc_hd__decap_40_12
XFILLER_7_305 vssd1 vccd1 vssd1 vccd1 X2_sky130_ef_sc_hd__decap_40_12
XFILLER_11_389 vssd1 vccd1 vccd1 vssd1 X2_sky130_fd_sc_hd__fill_2
XFILLER_7_349 vssd1 vccd1 vssd1 vccd1 X2_sky130_ef_sc_hd__decap_40_12
XTAP_TAPCELL_ROW_98_1294 vccd1 vssd1 X2_sky130_fd_sc_hd__tapvpwrvgnd_1
XFILLER_97_109 vssd1 vccd1 vccd1 vssd1 X2_sky130_fd_sc_hd__fill_2
XFILLER_78_301 vssd1 vccd1 vccd1 vssd1 X2_sky130_fd_sc_hd__fill_4
XFILLER_78_345 vssd1 vccd1 vssd1 vccd1 X2_sky130_ef_sc_hd__decap_40_12
XFILLER_38_209 vssd1 vccd1 vssd1 vccd1 X2_sky130_ef_sc_hd__decap_40_12
XFILLER_93_337 vccd1 vssd1 vccd1 vssd1 X2_sky130_fd_sc_hd__fill_1
XFILLER_78_389 vssd1 vccd1 vssd1 vccd1 X2_sky130_ef_sc_hd__decap_40_12
XFILLER_66_529 vssd1 vccd1 vccd1 vssd1 X2_sky130_fd_sc_hd__fill_2
XFILLER_19_445 vssd1 vccd1 vccd1 vssd1 X2_sky130_fd_sc_hd__fill_2
XFILLER_46_220 vssd1 vccd1 vssd1 vccd1 X2_sky130_ef_sc_hd__decap_40_12
XFILLER_46_253 vccd1 vssd1 vccd1 vssd1 X2_sky130_fd_sc_hd__fill_1
XANTENNA__547__CLK _553_/CLK vssd1 vccd1 vccd1 vssd1 X2_sky130_fd_sc_hd__diode_2
XFILLER_61_223 vccd1 vssd1 vccd1 vssd1 X2_sky130_fd_sc_hd__fill_1
XFILLER_21_109 vssd1 vccd1 vccd1 vssd1 X2_sky130_fd_sc_hd__fill_2
XFILLER_61_278 vssd1 vccd1 vccd1 vssd1 X2_sky130_fd_sc_hd__fill_2
XTAP_TAPCELL_ROW_12_351 vccd1 vssd1 X2_sky130_fd_sc_hd__tapvpwrvgnd_1
XTAP_TAPCELL_ROW_40_660 vccd1 vssd1 X2_sky130_fd_sc_hd__tapvpwrvgnd_1
Xinput11 vssd1 vccd1 _538_/D adc_data_in[8] vccd1 vssd1 X2_sky130_fd_sc_hd__clkbuf_1
Xinput22 vssd1 vccd1 _266_/C wbs_cyc_i vccd1 vssd1 X2_sky130_fd_sc_hd__buf_1
X_319_ vccd1 vssd1 vccd1 vssd1 _581_/Q _291_/B _319_/X _310_/Y _537_/Q _303_/X X2_sky130_fd_sc_hd__a221o_1
Xinput33 vssd1 vccd1 _447_/A1 wbs_dat_i[4] vccd1 vssd1 X2_sky130_fd_sc_hd__buf_1
XFILLER_88_109 vssd1 vccd1 vssd1 vccd1 X2_sky130_ef_sc_hd__decap_40_12
XFILLER_96_153 vssd1 vccd1 vssd1 vccd1 X2_sky130_ef_sc_hd__decap_40_12
XFILLER_84_304 vssd1 vccd1 vccd1 vssd1 X2_sky130_fd_sc_hd__fill_4
XFILLER_96_197 vssd1 vccd1 vssd1 vccd1 X2_sky130_ef_sc_hd__decap_40_12
XFILLER_69_389 vssd1 vccd1 vccd1 vssd1 X2_sky130_fd_sc_hd__fill_2
XFILLER_57_529 vssd1 vccd1 vssd1 vccd1 X2_sky130_ef_sc_hd__decap_40_12
XFILLER_52_201 vssd1 vccd1 vccd1 vssd1 X2_sky130_fd_sc_hd__fill_4
XFILLER_12_109 vssd1 vccd1 vssd1 vccd1 X2_sky130_ef_sc_hd__decap_40_12
XFILLER_40_418 vssd1 vccd1 vccd1 vssd1 X2_sky130_fd_sc_hd__fill_2
XFILLER_80_587 vccd1 vssd1 vccd1 vssd1 X2_sky130_fd_sc_hd__fill_1
XFILLER_32_27 vccd1 vssd1 vccd1 vssd1 X2_sky130_fd_sc_hd__fill_1
XFILLER_20_153 vssd1 vccd1 vssd1 vccd1 X2_sky130_ef_sc_hd__decap_40_12
XFILLER_20_197 vssd1 vccd1 vssd1 vccd1 X2_sky130_ef_sc_hd__decap_40_12
XFILLER_0_503 vccd1 vssd1 vccd1 vssd1 X2_sky130_fd_sc_hd__fill_1
XFILLER_79_109 vssd1 vccd1 vccd1 vssd1 X2_sky130_fd_sc_hd__fill_2
XFILLER_75_337 vssd1 vccd1 vssd1 vccd1 X2_sky130_ef_sc_hd__decap_40_12
XFILLER_57_57 vssd1 vccd1 vssd1 vccd1 X2_sky130_ef_sc_hd__decap_40_12
XFILLER_28_253 vssd1 vccd1 vssd1 vccd1 X2_sky130_ef_sc_hd__decap_40_12
XFILLER_90_307 vccd1 vssd1 vccd1 vssd1 X2_sky130_fd_sc_hd__fill_1
XFILLER_90_329 vssd1 vccd1 vccd1 vssd1 X2_sky130_fd_sc_hd__fill_2
XFILLER_43_223 vccd1 vssd1 vccd1 vssd1 X2_sky130_fd_sc_hd__fill_1
XFILLER_31_429 vssd1 vccd1 vssd1 vccd1 X2_sky130_ef_sc_hd__decap_40_12
XFILLER_7_113 vssd1 vccd1 vssd1 vccd1 X2_sky130_ef_sc_hd__decap_40_12
XANTENNA__291__B _291_/B vssd1 vccd1 vccd1 vssd1 X2_sky130_fd_sc_hd__diode_2
XANTENNA__342__A2 _317_/C vssd1 vccd1 vccd1 vssd1 X2_sky130_fd_sc_hd__diode_2
XFILLER_98_53 vssd1 vccd1 vssd1 vccd1 X2_sky130_ef_sc_hd__decap_40_12
XFILLER_3_385 vssd1 vccd1 vccd1 vssd1 X2_sky130_fd_sc_hd__fill_4
XFILLER_98_97 vssd1 vccd1 vssd1 vccd1 X2_sky130_ef_sc_hd__decap_40_12
XFILLER_78_153 vssd1 vccd1 vssd1 vccd1 X2_sky130_ef_sc_hd__decap_40_12
XFILLER_94_613 vssd1 vccd1 vssd1 vccd1 X2_sky130_ef_sc_hd__decap_40_12
XFILLER_78_197 vssd1 vccd1 vssd1 vccd1 X2_sky130_ef_sc_hd__decap_40_12
XFILLER_93_167 vccd1 vssd1 vccd1 vssd1 X2_sky130_fd_sc_hd__fill_1
XFILLER_81_329 vssd1 vccd1 vccd1 vssd1 X2_sky130_fd_sc_hd__fill_4
XFILLER_47_573 vssd1 vccd1 vssd1 vccd1 X2_sky130_ef_sc_hd__decap_40_12
XTAP_TAPCELL_ROW_17_410 vccd1 vssd1 X2_sky130_fd_sc_hd__tapvpwrvgnd_1
XFILLER_34_201 vssd1 vccd1 vccd1 vssd1 X2_sky130_fd_sc_hd__fill_4
XFILLER_34_212 vssd1 vccd1 vssd1 vccd1 X2_sky130_ef_sc_hd__decap_40_12
XFILLER_62_565 vssd1 vccd1 vccd1 vssd1 X2_sky130_fd_sc_hd__fill_2
XFILLER_97_3 vssd1 vccd1 vssd1 vccd1 X2_sky130_ef_sc_hd__decap_40_12
XFILLER_62_587 vccd1 vssd1 vccd1 vssd1 X2_sky130_fd_sc_hd__fill_1
XANTENNA__443__A1_N _298_/A0 vssd1 vccd1 vccd1 vssd1 X2_sky130_fd_sc_hd__diode_2
XFILLER_30_473 vssd1 vccd1 vccd1 vssd1 X2_sky130_fd_sc_hd__fill_2
XANTENNA__482__A _517_/A vssd1 vccd1 vccd1 vssd1 X2_sky130_fd_sc_hd__diode_2
XANTENNA__333__A2 _291_/B vssd1 vccd1 vccd1 vssd1 X2_sky130_fd_sc_hd__diode_2
XFILLER_89_429 vssd1 vccd1 vssd1 vccd1 X2_sky130_ef_sc_hd__decap_40_12
XTAP_TAPCELL_ROW_73_1028 vccd1 vssd1 X2_sky130_fd_sc_hd__tapvpwrvgnd_1
XFILLER_85_613 vssd1 vccd1 vccd1 vssd1 X2_sky130_fd_sc_hd__fill_2
XFILLER_97_473 vssd1 vccd1 vssd1 vccd1 X2_sky130_ef_sc_hd__decap_40_12
XFILLER_27_27 vssd1 vccd1 vssd1 vccd1 X2_sky130_ef_sc_hd__decap_40_12
XFILLER_57_337 vccd1 vssd1 vccd1 vssd1 X2_sky130_fd_sc_hd__fill_1
XFILLER_72_307 vccd1 vssd1 vccd1 vssd1 X2_sky130_fd_sc_hd__fill_1
XFILLER_25_223 vccd1 vssd1 vccd1 vssd1 X2_sky130_fd_sc_hd__fill_1
XFILLER_84_189 vssd1 vccd1 vccd1 vssd1 X2_sky130_fd_sc_hd__fill_4
XFILLER_65_370 vssd1 vccd1 vssd1 vccd1 X2_sky130_ef_sc_hd__decap_40_12
XTAP_TAPCELL_ROW_84_1146 vccd1 vssd1 X2_sky130_fd_sc_hd__tapvpwrvgnd_1
XFILLER_13_429 vssd1 vccd1 vssd1 vccd1 X2_sky130_ef_sc_hd__decap_40_12
XFILLER_40_204 vssd1 vccd1 vccd1 vssd1 X2_sky130_fd_sc_hd__fill_2
XFILLER_40_226 vssd1 vccd1 vccd1 vssd1 X2_sky130_fd_sc_hd__fill_2
XFILLER_43_15 vssd1 vccd1 vssd1 vccd1 X2_sky130_ef_sc_hd__decap_40_12
XFILLER_21_473 vssd1 vccd1 vssd1 vccd1 X2_sky130_ef_sc_hd__decap_40_12
XTAP_TAPCELL_ROW_23_468 vccd1 vssd1 X2_sky130_fd_sc_hd__tapvpwrvgnd_1
XTAP_TAPCELL_ROW_51_777 vccd1 vssd1 X2_sky130_fd_sc_hd__tapvpwrvgnd_1
XFILLER_5_617 vssd1 vccd1 vccd1 vssd1 X2_sky130_fd_sc_hd__fill_8
XANTENNA__324__A2 _291_/B vssd1 vccd1 vccd1 vssd1 X2_sky130_fd_sc_hd__diode_2
XTAP_TAPCELL_ROW_95_1264 vccd1 vssd1 X2_sky130_fd_sc_hd__tapvpwrvgnd_1
XFILLER_0_322 vssd1 vccd1 vccd1 vssd1 X2_sky130_fd_sc_hd__fill_2
XFILLER_0_377 vssd1 vccd1 vccd1 vssd1 X2_sky130_fd_sc_hd__fill_4
XFILLER_88_473 vssd1 vccd1 vccd1 vssd1 X2_sky130_fd_sc_hd__fill_2
XFILLER_76_624 vccd1 vssd1 vccd1 vssd1 X2_sky130_fd_sc_hd__fill_1
XFILLER_76_613 vssd1 vccd1 vccd1 vssd1 X2_sky130_fd_sc_hd__fill_8
XFILLER_29_573 vssd1 vccd1 vssd1 vccd1 X2_sky130_ef_sc_hd__decap_40_12
XFILLER_75_167 vccd1 vssd1 vccd1 vssd1 X2_sky130_fd_sc_hd__fill_1
XTAP_TAPCELL_ROW_59_866 vccd1 vssd1 X2_sky130_fd_sc_hd__tapvpwrvgnd_1
XANTENNA_input17_A wbs_adr_i[3] vssd1 vccd1 vccd1 vssd1 X2_sky130_fd_sc_hd__diode_2
XFILLER_90_137 vssd1 vccd1 vccd1 vssd1 X2_sky130_fd_sc_hd__fill_2
XFILLER_84_77 vssd1 vccd1 vccd1 vssd1 X2_sky130_fd_sc_hd__fill_4
XFILLER_16_245 vssd1 vccd1 vccd1 vssd1 X2_sky130_fd_sc_hd__fill_4
X_584_ vssd1 vccd1 vccd1 vssd1 _609_/CLK _584_/D _504_/Y _584_/Q X2_sky130_fd_sc_hd__dfrtp_1
XFILLER_16_289 vssd1 vccd1 vssd1 vccd1 X2_sky130_ef_sc_hd__decap_40_12
XFILLER_17_93 vssd1 vccd1 vssd1 vccd1 X2_sky130_ef_sc_hd__decap_40_12
XFILLER_71_373 vssd1 vccd1 vssd1 vccd1 X2_sky130_ef_sc_hd__decap_40_12
XFILLER_44_587 vccd1 vssd1 vccd1 vssd1 X2_sky130_fd_sc_hd__fill_1
XFILLER_31_237 vssd1 vccd1 vssd1 vccd1 X2_sky130_ef_sc_hd__decap_40_12
XFILLER_12_473 vssd1 vccd1 vccd1 vssd1 X2_sky130_fd_sc_hd__fill_2
XFILLER_8_433 vssd1 vccd1 vssd1 vccd1 X2_sky130_ef_sc_hd__decap_40_12
XFILLER_33_81 vssd1 vccd1 vssd1 vccd1 X2_sky130_ef_sc_hd__decap_40_12
XFILLER_8_477 vssd1 vccd1 vssd1 vccd1 X2_sky130_ef_sc_hd__decap_40_12
XFILLER_3_193 vssd1 vccd1 vssd1 vccd1 X2_sky130_ef_sc_hd__decap_40_12
XFILLER_100_209 vssd1 vccd1 vssd1 vccd1 X2_sky130_ef_sc_hd__decap_40_12
XFILLER_79_473 vssd1 vccd1 vssd1 vccd1 X2_sky130_ef_sc_hd__decap_40_12
XFILLER_67_624 vccd1 vssd1 vccd1 vssd1 X2_sky130_fd_sc_hd__fill_1
XFILLER_67_602 vssd1 vccd1 vccd1 vssd1 X2_sky130_fd_sc_hd__fill_2
XFILLER_12_3 vssd1 vccd1 vssd1 vccd1 X2_sky130_ef_sc_hd__decap_40_12
XFILLER_39_337 vssd1 vccd1 vssd1 vccd1 X2_sky130_ef_sc_hd__decap_40_12
XFILLER_39_359 vccd1 vssd1 vccd1 vssd1 X2_sky130_fd_sc_hd__fill_1
XFILLER_94_421 vssd1 vccd1 vssd1 vccd1 X2_sky130_ef_sc_hd__decap_40_12
XFILLER_54_307 vccd1 vssd1 vccd1 vssd1 X2_sky130_fd_sc_hd__fill_1
XANTENNA__477__A _517_/A vssd1 vccd1 vccd1 vssd1 X2_sky130_fd_sc_hd__diode_2
XFILLER_81_137 vssd1 vccd1 vssd1 vccd1 X2_sky130_ef_sc_hd__decap_40_12
XFILLER_66_189 vssd1 vccd1 vccd1 vssd1 X2_sky130_fd_sc_hd__fill_4
XFILLER_50_557 vssd1 vccd1 vssd1 vccd1 X2_sky130_ef_sc_hd__decap_40_12
XTAP_TAPCELL_ROW_20_438 vccd1 vssd1 X2_sky130_fd_sc_hd__tapvpwrvgnd_1
XFILLER_30_292 vssd1 vccd1 vssd1 vccd1 X2_sky130_ef_sc_hd__decap_40_12
XANTENNA__306__A2 _303_/X vssd1 vccd1 vccd1 vssd1 X2_sky130_fd_sc_hd__diode_2
XFILLER_89_237 vssd1 vccd1 vssd1 vccd1 X2_sky130_ef_sc_hd__decap_40_12
XFILLER_38_15 vssd1 vccd1 vssd1 vccd1 X2_sky130_ef_sc_hd__decap_40_12
XANTENNA_input9_A adc_data_in[6] vssd1 vccd1 vccd1 vssd1 X2_sky130_fd_sc_hd__diode_2
XFILLER_58_624 vccd1 vssd1 vccd1 vssd1 X2_sky130_fd_sc_hd__fill_1
XFILLER_97_281 vssd1 vccd1 vssd1 vccd1 X2_sky130_ef_sc_hd__decap_40_12
XFILLER_57_167 vccd1 vssd1 vccd1 vssd1 X2_sky130_fd_sc_hd__fill_1
XTAP_TAPCELL_ROW_28_527 vccd1 vssd1 X2_sky130_fd_sc_hd__tapvpwrvgnd_1
XFILLER_72_137 vssd1 vccd1 vccd1 vssd1 X2_sky130_fd_sc_hd__fill_2
XTAP_TAPCELL_ROW_56_836 vccd1 vssd1 X2_sky130_fd_sc_hd__tapvpwrvgnd_1
XFILLER_26_587 vccd1 vssd1 vccd1 vssd1 X2_sky130_fd_sc_hd__fill_1
XFILLER_13_237 vssd1 vccd1 vssd1 vccd1 X2_sky130_ef_sc_hd__decap_40_12
XFILLER_21_281 vssd1 vccd1 vssd1 vccd1 X2_sky130_ef_sc_hd__decap_40_12
XFILLER_5_447 vccd1 vssd1 vccd1 vssd1 X2_sky130_fd_sc_hd__fill_1
XFILLER_79_55 vccd1 vssd1 vccd1 vssd1 X2_sky130_fd_sc_hd__fill_1
XFILLER_0_141 vssd1 vccd1 vssd1 vccd1 X2_sky130_ef_sc_hd__decap_40_12
XFILLER_49_624 vccd1 vssd1 vccd1 vssd1 X2_sky130_fd_sc_hd__fill_1
XFILLER_76_421 vssd1 vccd1 vssd1 vccd1 X2_sky130_ef_sc_hd__decap_40_12
XFILLER_36_307 vccd1 vssd1 vccd1 vssd1 X2_sky130_fd_sc_hd__fill_1
XFILLER_64_616 vssd1 vccd1 vccd1 vssd1 X2_sky130_fd_sc_hd__fill_4
XFILLER_28_81 vssd1 vccd1 vccd1 vssd1 X2_sky130_fd_sc_hd__fill_2
XFILLER_63_137 vssd1 vccd1 vssd1 vccd1 X2_sky130_ef_sc_hd__decap_40_12
XFILLER_48_189 vssd1 vccd1 vccd1 vssd1 X2_sky130_fd_sc_hd__fill_4
X_567_ vssd1 vccd1 vccd1 vssd1 _601_/CLK _567_/D _487_/Y _567_/Q X2_sky130_fd_sc_hd__dfrtp_1
XFILLER_71_181 vssd1 vccd1 vssd1 vccd1 X2_sky130_ef_sc_hd__decap_40_12
X_498_ vccd1 vssd1 vccd1 vssd1 _498_/Y _517_/A X2_sky130_fd_sc_hd__inv_2
XFILLER_32_579 vssd1 vccd1 vccd1 vssd1 X2_sky130_fd_sc_hd__fill_4
XFILLER_99_557 vssd1 vccd1 vccd1 vssd1 X2_sky130_fd_sc_hd__fill_2
XFILLER_101_529 vssd1 vccd1 vccd1 vssd1 X2_sky130_fd_sc_hd__fill_2
XFILLER_79_281 vssd1 vccd1 vssd1 vccd1 X2_sky130_ef_sc_hd__decap_40_12
XFILLER_39_167 vccd1 vssd1 vccd1 vssd1 X2_sky130_fd_sc_hd__fill_1
XFILLER_94_251 vccd1 vssd1 vccd1 vssd1 X2_sky130_fd_sc_hd__fill_1
XFILLER_27_329 vssd1 vccd1 vccd1 vssd1 X2_sky130_fd_sc_hd__fill_4
XFILLER_82_413 vssd1 vccd1 vccd1 vssd1 X2_sky130_fd_sc_hd__fill_4
XFILLER_82_457 vssd1 vccd1 vssd1 vccd1 X2_sky130_ef_sc_hd__decap_40_12
XFILLER_54_137 vssd1 vccd1 vccd1 vssd1 X2_sky130_fd_sc_hd__fill_2
XTAP_TAPCELL_ROW_53_806 vccd1 vssd1 X2_sky130_fd_sc_hd__tapvpwrvgnd_1
XFILLER_23_557 vssd1 vccd1 vccd1 vssd1 X2_sky130_fd_sc_hd__fill_2
XTAP_TAPCELL_ROW_81_1116 vccd1 vssd1 X2_sky130_fd_sc_hd__tapvpwrvgnd_1
XFILLER_50_365 vssd1 vccd1 vssd1 vccd1 X2_sky130_ef_sc_hd__decap_40_12
XTAP_TAPCELL_ROW_33_585 vccd1 vssd1 X2_sky130_fd_sc_hd__tapvpwrvgnd_1
XTAP_TAPCELL_ROW_61_894 vccd1 vssd1 X2_sky130_fd_sc_hd__tapvpwrvgnd_1
XFILLER_40_27 vccd1 vssd1 vccd1 vssd1 X2_sky130_fd_sc_hd__fill_1
XTAP_TAPCELL_ROW_79_1089 vccd1 vssd1 X2_sky130_fd_sc_hd__tapvpwrvgnd_1
XFILLER_2_417 vssd1 vccd1 vccd1 vssd1 X2_sky130_fd_sc_hd__fill_2
XTAP_TAPCELL_ROW_92_1234 vccd1 vssd1 X2_sky130_fd_sc_hd__tapvpwrvgnd_1
XFILLER_49_69 vssd1 vccd1 vssd1 vccd1 X2_sky130_ef_sc_hd__decap_40_12
XFILLER_58_421 vssd1 vccd1 vssd1 vccd1 X2_sky130_ef_sc_hd__decap_40_12
XTAP_TAPCELL_ROW_5_277 vccd1 vssd1 X2_sky130_fd_sc_hd__tapvpwrvgnd_1
XFILLER_18_307 vccd1 vssd1 vccd1 vssd1 X2_sky130_fd_sc_hd__fill_1
XFILLER_85_273 vssd1 vccd1 vccd1 vssd1 X2_sky130_fd_sc_hd__fill_4
XTAP_TAPCELL_ROW_69_983 vccd1 vssd1 X2_sky130_fd_sc_hd__tapvpwrvgnd_1
XFILLER_65_57 vssd1 vccd1 vssd1 vccd1 X2_sky130_ef_sc_hd__decap_40_12
XFILLER_45_137 vssd1 vccd1 vssd1 vccd1 X2_sky130_ef_sc_hd__decap_40_12
XFILLER_14_513 vssd1 vccd1 vssd1 vccd1 X2_sky130_ef_sc_hd__decap_40_12
X_421_ vccd1 vssd1 _421_/X _420_/Y _416_/Y _406_/B _425_/D vssd1 vccd1 X2_sky130_fd_sc_hd__a31o_1
XFILLER_14_557 vssd1 vccd1 vssd1 vccd1 X2_sky130_ef_sc_hd__decap_40_12
X_352_ vssd1 vccd1 vssd1 vccd1 hold85/X _406_/B _539_/Q X2_sky130_fd_sc_hd__nand2b_2
XFILLER_53_181 vssd1 vccd1 vccd1 vssd1 X2_sky130_fd_sc_hd__fill_4
XTAP_TAPCELL_ROW_101_1341 vccd1 vssd1 X2_sky130_fd_sc_hd__tapvpwrvgnd_1
XTAP_TAPCELL_ROW_101_1330 vccd1 vssd1 X2_sky130_fd_sc_hd__tapvpwrvgnd_1
X_283_ vssd1 vccd1 vccd1 vssd1 _596_/D hold72/X _289_/S _449_/A1 X2_sky130_fd_sc_hd__mux2_1
XFILLER_41_387 vssd1 vccd1 vccd1 vssd1 X2_sky130_fd_sc_hd__fill_4
XFILLER_14_83 vccd1 vssd1 vccd1 vssd1 X2_sky130_fd_sc_hd__fill_1
XFILLER_5_277 vssd1 vccd1 vccd1 vssd1 X2_sky130_fd_sc_hd__fill_2
XFILLER_1_461 vssd1 vccd1 vssd1 vccd1 X2_sky130_ef_sc_hd__decap_40_12
XFILLER_37_605 vccd1 vssd1 vccd1 vssd1 X2_sky130_fd_sc_hd__fill_1
XFILLER_76_251 vccd1 vssd1 vccd1 vssd1 X2_sky130_fd_sc_hd__fill_1
Xinput9 vssd1 vccd1 _536_/D adc_data_in[6] vccd1 vssd1 X2_sky130_fd_sc_hd__buf_1
XFILLER_36_137 vssd1 vccd1 vccd1 vssd1 X2_sky130_fd_sc_hd__fill_2
XFILLER_91_221 vssd1 vccd1 vccd1 vssd1 X2_sky130_fd_sc_hd__fill_2
XFILLER_64_457 vssd1 vccd1 vccd1 vssd1 X2_sky130_fd_sc_hd__fill_8
XFILLER_17_373 vssd1 vccd1 vssd1 vccd1 X2_sky130_ef_sc_hd__decap_40_12
XFILLER_52_619 vssd1 vccd1 vccd1 vssd1 X2_sky130_fd_sc_hd__fill_2
XFILLER_32_321 vssd1 vccd1 vssd1 vccd1 X2_sky130_ef_sc_hd__decap_40_12
XFILLER_32_365 vssd1 vccd1 vssd1 vccd1 X2_sky130_ef_sc_hd__decap_40_12
XFILLER_9_561 vssd1 vccd1 vssd1 vccd1 X2_sky130_ef_sc_hd__decap_40_12
XTAP_TAPCELL_ROW_30_555 vccd1 vssd1 X2_sky130_fd_sc_hd__tapvpwrvgnd_1
XANTENNA__490__A _525_/A vssd1 vccd1 vccd1 vssd1 X2_sky130_fd_sc_hd__diode_2
XFILLER_99_354 vssd1 vccd1 vccd1 vssd1 X2_sky130_fd_sc_hd__fill_2
XFILLER_87_505 vssd1 vccd1 vssd1 vccd1 X2_sky130_ef_sc_hd__decap_40_12
XFILLER_101_304 vssd1 vccd1 vccd1 vssd1 X2_sky130_fd_sc_hd__fill_4
XFILLER_101_337 vssd1 vccd1 vccd1 vssd1 X2_sky130_fd_sc_hd__fill_2
XFILLER_19_39 vssd1 vccd1 vssd1 vccd1 X2_sky130_ef_sc_hd__decap_40_12
XTAP_TAPCELL_ROW_2_247 vccd1 vssd1 X2_sky130_fd_sc_hd__tapvpwrvgnd_1
XFILLER_67_284 vssd1 vccd1 vccd1 vssd1 X2_sky130_fd_sc_hd__fill_8
XFILLER_67_273 vssd1 vccd1 vccd1 vssd1 X2_sky130_fd_sc_hd__fill_2
XFILLER_27_137 vssd1 vccd1 vssd1 vccd1 X2_sky130_ef_sc_hd__decap_40_12
XTAP_TAPCELL_ROW_38_633 vccd1 vssd1 X2_sky130_fd_sc_hd__tapvpwrvgnd_1
XFILLER_82_221 vssd1 vccd1 vssd1 vccd1 X2_sky130_ef_sc_hd__decap_40_12
XTAP_TAPCELL_ROW_66_942 vccd1 vssd1 X2_sky130_fd_sc_hd__tapvpwrvgnd_1
XFILLER_82_265 vssd1 vccd1 vssd1 vccd1 X2_sky130_ef_sc_hd__decap_40_12
XFILLER_43_619 vccd1 vssd1 vccd1 vssd1 X2_sky130_fd_sc_hd__fill_1
XFILLER_35_181 vssd1 vccd1 vccd1 vssd1 X2_sky130_fd_sc_hd__fill_2
XFILLER_11_505 vssd1 vccd1 vssd1 vccd1 X2_sky130_ef_sc_hd__decap_40_12
XFILLER_51_15 vssd1 vccd1 vssd1 vccd1 X2_sky130_ef_sc_hd__decap_40_12
XFILLER_50_195 vccd1 vssd1 vccd1 vssd1 X2_sky130_fd_sc_hd__fill_1
XFILLER_58_251 vccd1 vssd1 vccd1 vssd1 X2_sky130_fd_sc_hd__fill_1
XFILLER_100_370 vssd1 vccd1 vccd1 vssd1 X2_sky130_fd_sc_hd__fill_2
XFILLER_58_273 vssd1 vccd1 vccd1 vssd1 X2_sky130_fd_sc_hd__fill_4
XFILLER_18_137 vssd1 vccd1 vccd1 vssd1 X2_sky130_fd_sc_hd__fill_2
XFILLER_73_221 vssd1 vccd1 vccd1 vssd1 X2_sky130_fd_sc_hd__fill_2
XFILLER_46_457 vssd1 vccd1 vssd1 vccd1 X2_sky130_ef_sc_hd__decap_40_12
XFILLER_61_405 vssd1 vccd1 vssd1 vccd1 X2_sky130_ef_sc_hd__decap_40_12
XFILLER_14_321 vssd1 vccd1 vssd1 vccd1 X2_sky130_ef_sc_hd__decap_40_12
XFILLER_92_77 vssd1 vccd1 vccd1 vssd1 X2_sky130_fd_sc_hd__fill_4
XFILLER_61_449 vssd1 vccd1 vssd1 vccd1 X2_sky130_ef_sc_hd__decap_40_12
XFILLER_14_365 vssd1 vccd1 vssd1 vccd1 X2_sky130_ef_sc_hd__decap_40_12
X_404_ vccd1 vssd1 vccd1 vssd1 _403_/Y _555_/D _425_/D _404_/X X2_sky130_fd_sc_hd__a21o_1
XFILLER_25_93 vssd1 vccd1 vssd1 vccd1 X2_sky130_ef_sc_hd__decap_40_12
XFILLER_41_173 vssd1 vccd1 vccd1 vssd1 X2_sky130_fd_sc_hd__fill_2
X_335_ vccd1 vssd1 vccd1 vssd1 _576_/Q _291_/B _335_/X _317_/C _547_/D _303_/X X2_sky130_fd_sc_hd__a221o_1
X_266_ _303_/A _291_/A _266_/A _266_/C vccd1 vssd1 vccd1 vssd1 X2_sky130_fd_sc_hd__and3_2
XFILLER_6_531 vccd1 vssd1 vccd1 vssd1 X2_sky130_fd_sc_hd__fill_1
XFILLER_41_81 vssd1 vccd1 vssd1 vccd1 X2_sky130_ef_sc_hd__decap_40_12
XFILLER_69_505 vssd1 vccd1 vssd1 vccd1 X2_sky130_ef_sc_hd__decap_40_12
XFILLER_96_324 vccd1 vssd1 vccd1 vssd1 X2_sky130_fd_sc_hd__fill_1
XFILLER_2_53 vssd1 vccd1 vssd1 vccd1 X2_sky130_ef_sc_hd__decap_40_12
XPHY_EDGE_ROW_10_Right_10 vccd1 vssd1 vccd1 vssd1 X2_sky130_fd_sc_hd__decap_3
XFILLER_49_273 vssd1 vccd1 vccd1 vssd1 X2_sky130_fd_sc_hd__fill_4
XFILLER_2_97 vssd1 vccd1 vssd1 vccd1 X2_sky130_ef_sc_hd__decap_40_12
XFILLER_37_435 vssd1 vccd1 vccd1 vssd1 X2_sky130_fd_sc_hd__fill_2
XFILLER_64_221 vssd1 vccd1 vssd1 vccd1 X2_sky130_ef_sc_hd__decap_40_12
XTAP_TAPCELL_ROW_35_603 vccd1 vssd1 X2_sky130_fd_sc_hd__tapvpwrvgnd_1
XFILLER_92_585 vssd1 vccd1 vccd1 vssd1 X2_sky130_fd_sc_hd__fill_2
XANTENNA__485__A _521_/A vssd1 vccd1 vccd1 vssd1 X2_sky130_fd_sc_hd__diode_2
XFILLER_64_265 vssd1 vccd1 vssd1 vccd1 X2_sky130_ef_sc_hd__decap_40_12
XTAP_TAPCELL_ROW_63_912 vccd1 vssd1 X2_sky130_fd_sc_hd__tapvpwrvgnd_1
XFILLER_17_181 vssd1 vccd1 vssd1 vccd1 X2_sky130_ef_sc_hd__decap_40_12
XFILLER_64_287 vssd1 vccd1 vssd1 vccd1 X2_sky130_ef_sc_hd__decap_40_12
XTAP_TAPCELL_ROW_15_382 vccd1 vssd1 X2_sky130_fd_sc_hd__tapvpwrvgnd_1
XFILLER_20_357 vssd1 vccd1 vccd1 vssd1 X2_sky130_fd_sc_hd__fill_4
XFILLER_32_195 vccd1 vssd1 vccd1 vssd1 X2_sky130_fd_sc_hd__fill_1
XTAP_TAPCELL_ROW_43_691 vccd1 vssd1 X2_sky130_fd_sc_hd__tapvpwrvgnd_1
XFILLER_9_391 vccd1 vssd1 vccd1 vssd1 X2_sky130_fd_sc_hd__fill_1
XTAP_TAPCELL_ROW_76_1059 vccd1 vssd1 X2_sky130_fd_sc_hd__tapvpwrvgnd_1
XFILLER_87_335 vccd1 vssd1 vccd1 vssd1 X2_sky130_fd_sc_hd__fill_1
XFILLER_28_413 vssd1 vccd1 vccd1 vssd1 X2_sky130_fd_sc_hd__fill_4
XFILLER_101_167 vccd1 vssd1 vccd1 vssd1 X2_sky130_fd_sc_hd__fill_1
XFILLER_68_582 vssd1 vccd1 vccd1 vssd1 X2_sky130_fd_sc_hd__fill_4
XFILLER_46_15 vssd1 vccd1 vssd1 vccd1 X2_sky130_ef_sc_hd__decap_40_12
XFILLER_28_457 vssd1 vccd1 vssd1 vccd1 X2_sky130_ef_sc_hd__decap_40_12
XFILLER_83_541 vssd1 vccd1 vssd1 vccd1 X2_sky130_ef_sc_hd__decap_40_12
XFILLER_55_221 vssd1 vccd1 vccd1 vssd1 X2_sky130_fd_sc_hd__fill_2
XTAP_TAPCELL_ROW_87_1177 vccd1 vssd1 X2_sky130_fd_sc_hd__tapvpwrvgnd_1
XFILLER_83_585 vssd1 vccd1 vssd1 vccd1 X2_sky130_ef_sc_hd__decap_40_12
XFILLER_55_287 vccd1 vssd1 vccd1 vssd1 X2_sky130_fd_sc_hd__fill_1
XFILLER_43_449 vssd1 vccd1 vssd1 vccd1 X2_sky130_ef_sc_hd__decap_40_12
XANTENNA__545__D hold5/X vssd1 vccd1 vccd1 vssd1 X2_sky130_fd_sc_hd__diode_2
XFILLER_11_335 vccd1 vssd1 vccd1 vssd1 X2_sky130_fd_sc_hd__fill_1
XFILLER_7_317 vssd1 vccd1 vssd1 vccd1 X2_sky130_ef_sc_hd__decap_40_12
XFILLER_3_501 vssd1 vccd1 vccd1 vssd1 X2_sky130_fd_sc_hd__fill_2
XFILLER_11_51 vssd1 vccd1 vccd1 vssd1 X2_sky130_fd_sc_hd__fill_4
XTAP_TAPCELL_ROW_98_1295 vccd1 vssd1 X2_sky130_fd_sc_hd__tapvpwrvgnd_1
XFILLER_87_55 vccd1 vssd1 vccd1 vssd1 X2_sky130_fd_sc_hd__fill_1
XFILLER_78_357 vssd1 vccd1 vccd1 vssd1 X2_sky130_fd_sc_hd__fill_4
XFILLER_46_232 vssd1 vccd1 vccd1 vssd1 X2_sky130_fd_sc_hd__fill_4
XFILLER_36_81 vssd1 vccd1 vccd1 vssd1 X2_sky130_fd_sc_hd__fill_2
XFILLER_61_246 vssd1 vccd1 vccd1 vssd1 X2_sky130_fd_sc_hd__fill_2
XFILLER_14_195 vccd1 vssd1 vccd1 vssd1 X2_sky130_fd_sc_hd__fill_1
XFILLER_42_493 vssd1 vccd1 vccd1 vssd1 X2_sky130_fd_sc_hd__fill_2
XTAP_TAPCELL_ROW_12_352 vccd1 vssd1 X2_sky130_fd_sc_hd__tapvpwrvgnd_1
XTAP_TAPCELL_ROW_40_661 vccd1 vssd1 X2_sky130_fd_sc_hd__tapvpwrvgnd_1
X_318_ vccd1 vssd1 vccd1 vssd1 hold28/X _303_/X _318_/X _304_/X _598_/Q _317_/X X2_sky130_fd_sc_hd__a221o_1
Xinput12 vssd1 vccd1 _539_/D adc_data_in[9] vccd1 vssd1 X2_sky130_fd_sc_hd__clkbuf_1
Xinput34 vssd1 vccd1 wbs_dat_i[5] _448_/A1 vccd1 vssd1 X2_sky130_fd_sc_hd__clkbuf_2
Xinput23 vssd1 vccd1 _301_/A0 wbs_dat_i[0] vccd1 vssd1 X2_sky130_fd_sc_hd__buf_1
XFILLER_6_361 vssd1 vccd1 vccd1 vssd1 X2_sky130_fd_sc_hd__fill_2
XFILLER_42_3 vccd1 vssd1 vccd1 vssd1 X2_sky130_fd_sc_hd__fill_1
XFILLER_96_121 vssd1 vccd1 vssd1 vccd1 X2_sky130_ef_sc_hd__decap_40_12
XFILLER_69_335 vccd1 vssd1 vccd1 vssd1 X2_sky130_fd_sc_hd__fill_1
XFILLER_96_165 vssd1 vccd1 vssd1 vccd1 X2_sky130_ef_sc_hd__decap_40_12
XFILLER_37_221 vssd1 vccd1 vccd1 vssd1 X2_sky130_fd_sc_hd__fill_2
XFILLER_84_349 vssd1 vccd1 vssd1 vccd1 X2_sky130_ef_sc_hd__decap_40_12
XFILLER_65_541 vssd1 vccd1 vssd1 vccd1 X2_sky130_ef_sc_hd__decap_40_12
XFILLER_25_405 vssd1 vccd1 vssd1 vccd1 X2_sky130_ef_sc_hd__decap_40_12
XTAP_TAPCELL_ROW_48_750 vccd1 vssd1 X2_sky130_fd_sc_hd__tapvpwrvgnd_1
XFILLER_16_29 vssd1 vccd1 vssd1 vccd1 X2_sky130_ef_sc_hd__decap_40_12
XFILLER_25_449 vssd1 vccd1 vssd1 vccd1 X2_sky130_ef_sc_hd__decap_40_12
XFILLER_80_533 vssd1 vccd1 vssd1 vccd1 X2_sky130_ef_sc_hd__decap_40_12
XFILLER_65_596 vssd1 vccd1 vssd1 vccd1 X2_sky130_ef_sc_hd__decap_40_12
XFILLER_52_224 vssd1 vccd1 vccd1 vssd1 X2_sky130_fd_sc_hd__fill_2
XFILLER_20_121 vssd1 vccd1 vssd1 vccd1 X2_sky130_ef_sc_hd__decap_40_12
XFILLER_20_165 vssd1 vccd1 vssd1 vccd1 X2_sky130_ef_sc_hd__decap_40_12
XFILLER_4_309 vssd1 vccd1 vssd1 vccd1 X2_sky130_ef_sc_hd__decap_40_12
XFILLER_0_559 vccd1 vssd1 vccd1 vssd1 X2_sky130_fd_sc_hd__fill_1
XFILLER_87_165 vssd1 vccd1 vccd1 vssd1 X2_sky130_fd_sc_hd__fill_2
XFILLER_75_305 vssd1 vccd1 vssd1 vccd1 X2_sky130_ef_sc_hd__decap_40_12
XFILLER_57_69 vssd1 vccd1 vssd1 vccd1 X2_sky130_ef_sc_hd__decap_40_12
XFILLER_28_221 vssd1 vccd1 vssd1 vccd1 X2_sky130_ef_sc_hd__decap_40_12
XFILLER_75_349 vssd1 vccd1 vssd1 vccd1 X2_sky130_ef_sc_hd__decap_40_12
XFILLER_28_265 vssd1 vccd1 vccd1 vssd1 X2_sky130_fd_sc_hd__fill_8
XFILLER_90_319 vssd1 vccd1 vccd1 vssd1 X2_sky130_fd_sc_hd__fill_2
XFILLER_83_393 vssd1 vccd1 vssd1 vccd1 X2_sky130_ef_sc_hd__decap_40_12
XFILLER_56_596 vssd1 vccd1 vssd1 vccd1 X2_sky130_ef_sc_hd__decap_40_12
XFILLER_73_57 vssd1 vccd1 vssd1 vccd1 X2_sky130_ef_sc_hd__decap_40_12
XFILLER_43_279 vccd1 vssd1 vccd1 vssd1 X2_sky130_fd_sc_hd__fill_1
XFILLER_11_165 vssd1 vccd1 vccd1 vssd1 X2_sky130_fd_sc_hd__fill_2
XFILLER_7_125 vssd1 vccd1 vssd1 vccd1 X2_sky130_ef_sc_hd__decap_40_12
XFILLER_7_169 vssd1 vccd1 vssd1 vccd1 X2_sky130_ef_sc_hd__decap_40_12
XFILLER_22_83 vccd1 vssd1 vccd1 vssd1 X2_sky130_fd_sc_hd__fill_1
XFILLER_98_65 vssd1 vccd1 vssd1 vccd1 X2_sky130_ef_sc_hd__decap_40_12
XFILLER_78_121 vssd1 vccd1 vssd1 vccd1 X2_sky130_ef_sc_hd__decap_40_12
XFILLER_93_113 vssd1 vccd1 vssd1 vccd1 X2_sky130_ef_sc_hd__decap_40_12
XFILLER_78_165 vssd1 vccd1 vssd1 vccd1 X2_sky130_ef_sc_hd__decap_40_12
XFILLER_66_305 vssd1 vccd1 vccd1 vssd1 X2_sky130_fd_sc_hd__fill_2
XFILLER_19_221 vssd1 vccd1 vccd1 vssd1 X2_sky130_fd_sc_hd__fill_2
XTAP_TAPCELL_ROW_17_411 vccd1 vssd1 X2_sky130_fd_sc_hd__tapvpwrvgnd_1
XFILLER_34_224 vssd1 vccd1 vccd1 vssd1 X2_sky130_fd_sc_hd__fill_2
XFILLER_62_533 vssd1 vccd1 vssd1 vccd1 X2_sky130_ef_sc_hd__decap_40_12
XFILLER_47_585 vssd1 vccd1 vssd1 vccd1 X2_sky130_ef_sc_hd__decap_40_12
XTAP_TAPCELL_ROW_45_720 vccd1 vssd1 X2_sky130_fd_sc_hd__tapvpwrvgnd_1
XFILLER_22_419 vccd1 vssd1 vccd1 vssd1 X2_sky130_fd_sc_hd__fill_1
XFILLER_8_41 vssd1 vccd1 vssd1 vccd1 X2_sky130_ef_sc_hd__decap_40_12
XFILLER_8_85 vssd1 vccd1 vssd1 vccd1 X2_sky130_ef_sc_hd__decap_40_12
XANTENNA__318__B1 _304_/X vssd1 vccd1 vccd1 vssd1 X2_sky130_fd_sc_hd__diode_2
XTAP_TAPCELL_ROW_73_1018 vccd1 vssd1 X2_sky130_fd_sc_hd__tapvpwrvgnd_1
XFILLER_97_485 vssd1 vccd1 vssd1 vccd1 X2_sky130_ef_sc_hd__decap_40_12
XFILLER_69_165 vssd1 vccd1 vccd1 vssd1 X2_sky130_fd_sc_hd__fill_2
XFILLER_38_530 vssd1 vccd1 vccd1 vssd1 X2_sky130_fd_sc_hd__fill_2
XFILLER_27_39 vssd1 vccd1 vssd1 vccd1 X2_sky130_ef_sc_hd__decap_40_12
XFILLER_38_585 vssd1 vccd1 vccd1 vssd1 X2_sky130_fd_sc_hd__fill_2
XFILLER_65_393 vssd1 vccd1 vssd1 vccd1 X2_sky130_ef_sc_hd__decap_40_12
XFILLER_65_382 vssd1 vccd1 vccd1 vssd1 X2_sky130_fd_sc_hd__fill_8
XTAP_TAPCELL_ROW_84_1147 vccd1 vssd1 X2_sky130_fd_sc_hd__tapvpwrvgnd_1
XFILLER_25_279 vccd1 vssd1 vccd1 vssd1 X2_sky130_fd_sc_hd__fill_1
XFILLER_80_363 vccd1 vssd1 vccd1 vssd1 X2_sky130_fd_sc_hd__fill_1
XFILLER_43_27 vssd1 vccd1 vssd1 vccd1 X2_sky130_ef_sc_hd__decap_40_12
XFILLER_33_290 vssd1 vccd1 vccd1 vssd1 X2_sky130_fd_sc_hd__fill_2
XFILLER_21_441 vssd1 vccd1 vccd1 vssd1 X2_sky130_fd_sc_hd__fill_4
XTAP_TAPCELL_ROW_23_469 vccd1 vssd1 X2_sky130_fd_sc_hd__tapvpwrvgnd_1
XTAP_TAPCELL_ROW_51_778 vccd1 vssd1 X2_sky130_fd_sc_hd__tapvpwrvgnd_1
XFILLER_21_485 vssd1 vccd1 vssd1 vccd1 X2_sky130_ef_sc_hd__decap_40_12
XFILLER_4_139 vccd1 vssd1 vccd1 vssd1 X2_sky130_fd_sc_hd__fill_1
XTAP_TAPCELL_ROW_95_1265 vccd1 vssd1 X2_sky130_fd_sc_hd__tapvpwrvgnd_1
XFILLER_0_301 vssd1 vccd1 vccd1 vssd1 X2_sky130_fd_sc_hd__fill_2
XANTENNA__537__CLK _553_/CLK vssd1 vccd1 vccd1 vssd1 X2_sky130_fd_sc_hd__diode_2
XFILLER_0_356 vssd1 vccd1 vccd1 vssd1 X2_sky130_fd_sc_hd__fill_2
XFILLER_0_389 vssd1 vccd1 vccd1 vssd1 X2_sky130_fd_sc_hd__fill_2
XFILLER_75_113 vssd1 vccd1 vssd1 vccd1 X2_sky130_ef_sc_hd__decap_40_12
XFILLER_29_541 vssd1 vccd1 vssd1 vccd1 X2_sky130_ef_sc_hd__decap_40_12
XFILLER_91_617 vssd1 vccd1 vccd1 vssd1 X2_sky130_fd_sc_hd__fill_8
XTAP_TAPCELL_ROW_59_867 vccd1 vssd1 X2_sky130_fd_sc_hd__tapvpwrvgnd_1
XFILLER_29_585 vssd1 vccd1 vssd1 vccd1 X2_sky130_ef_sc_hd__decap_40_12
XFILLER_44_533 vccd1 vssd1 vccd1 vssd1 X2_sky130_fd_sc_hd__fill_1
X_583_ vssd1 vccd1 vccd1 vssd1 _609_/CLK _583_/D _503_/Y _583_/Q X2_sky130_fd_sc_hd__dfrtp_1
XFILLER_31_205 vssd1 vccd1 vssd1 vccd1 X2_sky130_ef_sc_hd__decap_40_12
XFILLER_71_385 vssd1 vccd1 vccd1 vssd1 X2_sky130_fd_sc_hd__fill_4
XFILLER_31_249 vssd1 vccd1 vssd1 vccd1 X2_sky130_ef_sc_hd__decap_40_12
XFILLER_8_401 vssd1 vccd1 vssd1 vccd1 X2_sky130_ef_sc_hd__decap_40_12
XFILLER_8_445 vssd1 vccd1 vssd1 vccd1 X2_sky130_ef_sc_hd__decap_40_12
XFILLER_33_93 vssd1 vccd1 vssd1 vccd1 X2_sky130_ef_sc_hd__decap_40_12
XFILLER_8_489 vssd1 vccd1 vssd1 vccd1 X2_sky130_ef_sc_hd__decap_40_12
XFILLER_3_161 vssd1 vccd1 vccd1 vssd1 X2_sky130_fd_sc_hd__fill_4
XPHY_EDGE_ROW_89_Left_191 vccd1 vssd1 vccd1 vssd1 X2_sky130_fd_sc_hd__decap_3
XFILLER_98_249 vssd1 vccd1 vccd1 vssd1 X2_sky130_fd_sc_hd__fill_2
XFILLER_79_441 vssd1 vccd1 vccd1 vssd1 X2_sky130_fd_sc_hd__fill_4
XFILLER_79_485 vssd1 vccd1 vssd1 vccd1 X2_sky130_ef_sc_hd__decap_40_12
XFILLER_39_349 vssd1 vccd1 vccd1 vssd1 X2_sky130_fd_sc_hd__fill_8
XFILLER_94_433 vssd1 vccd1 vssd1 vccd1 X2_sky130_ef_sc_hd__decap_40_12
Xhold1 hold1/X hold1/A vccd1 vssd1 vssd1 vccd1 X2_sky130_fd_sc_hd__dlygate4sd3_1
XFILLER_94_477 vssd1 vccd1 vssd1 vccd1 X2_sky130_ef_sc_hd__decap_40_12
XFILLER_81_105 vssd1 vccd1 vccd1 vssd1 X2_sky130_fd_sc_hd__fill_4
XFILLER_81_149 vssd1 vccd1 vssd1 vccd1 X2_sky130_ef_sc_hd__decap_40_12
XFILLER_62_341 vccd1 vssd1 vccd1 vssd1 X2_sky130_fd_sc_hd__fill_1
XFILLER_47_393 vssd1 vccd1 vccd1 vssd1 X2_sky130_fd_sc_hd__fill_2
XPHY_EDGE_ROW_8_Right_8 vccd1 vssd1 vccd1 vssd1 X2_sky130_fd_sc_hd__decap_3
XFILLER_35_599 vssd1 vccd1 vccd1 vssd1 X2_sky130_fd_sc_hd__fill_4
XFILLER_62_363 vccd1 vssd1 vccd1 vssd1 X2_sky130_fd_sc_hd__fill_1
XFILLER_22_249 vssd1 vccd1 vccd1 vssd1 X2_sky130_fd_sc_hd__fill_2
XANTENNA__493__A _517_/A vssd1 vccd1 vccd1 vssd1 X2_sky130_fd_sc_hd__diode_2
XFILLER_50_569 vssd1 vccd1 vccd1 vssd1 X2_sky130_fd_sc_hd__fill_4
XTAP_TAPCELL_ROW_20_439 vccd1 vssd1 X2_sky130_fd_sc_hd__tapvpwrvgnd_1
XFILLER_1_109 vssd1 vccd1 vccd1 vssd1 X2_sky130_fd_sc_hd__fill_2
XFILLER_89_205 vssd1 vccd1 vssd1 vccd1 X2_sky130_ef_sc_hd__decap_40_12
XPHY_EDGE_ROW_39_Right_39 vccd1 vssd1 vccd1 vssd1 X2_sky130_fd_sc_hd__decap_3
XFILLER_89_249 vssd1 vccd1 vssd1 vccd1 X2_sky130_ef_sc_hd__decap_40_12
XFILLER_38_27 vccd1 vssd1 vccd1 vssd1 X2_sky130_fd_sc_hd__fill_1
XANTENNA_clkbuf_0_wb_clk_i_X clkbuf_0_wb_clk_i/X vssd1 vccd1 vccd1 vssd1 X2_sky130_fd_sc_hd__diode_2
XFILLER_97_293 vssd1 vccd1 vssd1 vccd1 X2_sky130_ef_sc_hd__decap_40_12
XFILLER_57_113 vssd1 vccd1 vssd1 vccd1 X2_sky130_ef_sc_hd__decap_40_12
XFILLER_73_617 vccd1 vssd1 vccd1 vssd1 X2_sky130_fd_sc_hd__fill_1
XTAP_TAPCELL_ROW_28_528 vccd1 vssd1 X2_sky130_fd_sc_hd__tapvpwrvgnd_1
XTAP_TAPCELL_ROW_56_837 vccd1 vssd1 X2_sky130_fd_sc_hd__tapvpwrvgnd_1
XFILLER_45_319 vssd1 vccd1 vccd1 vssd1 X2_sky130_fd_sc_hd__fill_2
XFILLER_26_533 vssd1 vccd1 vssd1 vccd1 X2_sky130_ef_sc_hd__decap_40_12
XFILLER_54_15 vssd1 vccd1 vssd1 vccd1 X2_sky130_ef_sc_hd__decap_40_12
XFILLER_53_341 vssd1 vccd1 vccd1 vssd1 X2_sky130_fd_sc_hd__fill_2
XFILLER_13_205 vssd1 vccd1 vssd1 vccd1 X2_sky130_ef_sc_hd__decap_40_12
XFILLER_41_525 vssd1 vccd1 vccd1 vssd1 X2_sky130_fd_sc_hd__fill_2
XFILLER_13_249 vssd1 vccd1 vssd1 vccd1 X2_sky130_ef_sc_hd__decap_40_12
XFILLER_80_193 vssd1 vccd1 vccd1 vssd1 X2_sky130_fd_sc_hd__fill_2
XPHY_EDGE_ROW_48_Right_48 vccd1 vssd1 vccd1 vssd1 X2_sky130_fd_sc_hd__decap_3
XFILLER_41_558 vssd1 vccd1 vccd1 vssd1 X2_sky130_fd_sc_hd__fill_2
XANTENNA__553__D _553_/D vssd1 vccd1 vccd1 vssd1 X2_sky130_fd_sc_hd__diode_2
XFILLER_21_293 vssd1 vccd1 vssd1 vccd1 X2_sky130_ef_sc_hd__decap_40_12
XPHY_EDGE_ROW_57_Right_57 vccd1 vssd1 vccd1 vssd1 X2_sky130_fd_sc_hd__decap_3
XFILLER_0_153 vssd1 vccd1 vssd1 vccd1 X2_sky130_ef_sc_hd__decap_40_12
XFILLER_0_197 vccd1 vssd1 vccd1 vssd1 X2_sky130_fd_sc_hd__fill_1
XFILLER_95_55 vccd1 vssd1 vccd1 vssd1 X2_sky130_fd_sc_hd__fill_1
XFILLER_76_433 vssd1 vccd1 vssd1 vccd1 X2_sky130_ef_sc_hd__decap_40_12
XFILLER_76_477 vssd1 vccd1 vssd1 vccd1 X2_sky130_ef_sc_hd__decap_40_12
XFILLER_63_105 vssd1 vccd1 vccd1 vssd1 X2_sky130_fd_sc_hd__fill_4
XFILLER_29_393 vssd1 vccd1 vssd1 vccd1 X2_sky130_ef_sc_hd__decap_40_12
XFILLER_91_447 vccd1 vssd1 vccd1 vssd1 X2_sky130_fd_sc_hd__fill_1
XFILLER_63_149 vssd1 vccd1 vssd1 vccd1 X2_sky130_ef_sc_hd__decap_40_12
XFILLER_32_503 vccd1 vssd1 vccd1 vssd1 X2_sky130_fd_sc_hd__fill_1
X_566_ vssd1 vccd1 vccd1 vssd1 _599_/CLK _566_/D _486_/Y _566_/Q X2_sky130_fd_sc_hd__dfrtp_1
XPHY_EDGE_ROW_66_Right_66 vccd1 vssd1 vccd1 vssd1 X2_sky130_fd_sc_hd__decap_3
XFILLER_44_363 vccd1 vssd1 vccd1 vssd1 X2_sky130_fd_sc_hd__fill_1
XFILLER_32_547 vccd1 vssd1 vccd1 vssd1 X2_sky130_fd_sc_hd__fill_1
XFILLER_71_193 vssd1 vccd1 vssd1 vccd1 X2_sky130_ef_sc_hd__decap_40_12
X_497_ vccd1 vssd1 vccd1 vssd1 _497_/Y _529_/A X2_sky130_fd_sc_hd__inv_2
XFILLER_44_81 vssd1 vccd1 vccd1 vssd1 X2_sky130_fd_sc_hd__fill_2
XFILLER_8_253 vssd1 vccd1 vssd1 vccd1 X2_sky130_ef_sc_hd__decap_40_12
XFILLER_99_503 vccd1 vssd1 vccd1 vssd1 X2_sky130_fd_sc_hd__fill_1
XPHY_EDGE_ROW_75_Right_75 vccd1 vssd1 vccd1 vssd1 X2_sky130_fd_sc_hd__decap_3
XFILLER_39_113 vssd1 vccd1 vssd1 vccd1 X2_sky130_ef_sc_hd__decap_40_12
XANTENNA__488__A _521_/A vssd1 vccd1 vccd1 vssd1 X2_sky130_fd_sc_hd__diode_2
XFILLER_79_293 vssd1 vccd1 vssd1 vccd1 X2_sky130_ef_sc_hd__decap_40_12
XFILLER_55_617 vssd1 vccd1 vccd1 vssd1 X2_sky130_fd_sc_hd__fill_4
XPHY_EDGE_ROW_84_Right_84 vccd1 vssd1 vccd1 vssd1 X2_sky130_fd_sc_hd__decap_3
XFILLER_82_469 vssd1 vccd1 vccd1 vssd1 X2_sky130_fd_sc_hd__fill_4
XFILLER_23_503 vccd1 vssd1 vccd1 vssd1 X2_sky130_fd_sc_hd__fill_1
XTAP_TAPCELL_ROW_81_1106 vccd1 vssd1 X2_sky130_fd_sc_hd__tapvpwrvgnd_1
XTAP_TAPCELL_ROW_53_807 vccd1 vssd1 X2_sky130_fd_sc_hd__tapvpwrvgnd_1
XFILLER_24_29 vssd1 vccd1 vssd1 vccd1 X2_sky130_ef_sc_hd__decap_40_12
XFILLER_35_385 vssd1 vccd1 vccd1 vssd1 X2_sky130_fd_sc_hd__fill_2
XFILLER_62_193 vssd1 vccd1 vccd1 vssd1 X2_sky130_fd_sc_hd__fill_2
XTAP_TAPCELL_ROW_33_586 vccd1 vssd1 X2_sky130_fd_sc_hd__tapvpwrvgnd_1
XTAP_TAPCELL_ROW_61_895 vccd1 vssd1 X2_sky130_fd_sc_hd__tapvpwrvgnd_1
XFILLER_50_377 vssd1 vccd1 vssd1 vccd1 X2_sky130_ef_sc_hd__decap_40_12
XPHY_EDGE_ROW_93_Right_93 vccd1 vssd1 vccd1 vssd1 X2_sky130_fd_sc_hd__decap_3
XTAP_TAPCELL_ROW_92_1235 vccd1 vssd1 X2_sky130_fd_sc_hd__tapvpwrvgnd_1
XFILLER_49_15 vssd1 vccd1 vssd1 vccd1 X2_sky130_ef_sc_hd__decap_40_12
XFILLER_58_433 vssd1 vccd1 vssd1 vccd1 X2_sky130_ef_sc_hd__decap_40_12
XTAP_TAPCELL_ROW_5_278 vccd1 vssd1 X2_sky130_fd_sc_hd__tapvpwrvgnd_1
XFILLER_46_606 vssd1 vccd1 vccd1 vssd1 X2_sky130_fd_sc_hd__fill_2
XFILLER_100_585 vssd1 vccd1 vccd1 vssd1 X2_sky130_fd_sc_hd__fill_2
XTAP_TAPCELL_ROW_69_984 vccd1 vssd1 X2_sky130_fd_sc_hd__tapvpwrvgnd_1
XFILLER_58_477 vssd1 vccd1 vssd1 vccd1 X2_sky130_ef_sc_hd__decap_40_12
XFILLER_45_105 vssd1 vccd1 vccd1 vssd1 X2_sky130_fd_sc_hd__fill_4
XFILLER_38_190 vssd1 vccd1 vccd1 vssd1 X2_sky130_fd_sc_hd__fill_4
XFILLER_73_447 vccd1 vssd1 vccd1 vssd1 X2_sky130_fd_sc_hd__fill_1
XFILLER_65_69 vssd1 vccd1 vssd1 vccd1 X2_sky130_ef_sc_hd__decap_40_12
XFILLER_61_609 vssd1 vccd1 vccd1 vssd1 X2_sky130_fd_sc_hd__fill_2
XFILLER_45_149 vssd1 vccd1 vssd1 vccd1 X2_sky130_ef_sc_hd__decap_40_12
XFILLER_26_363 vccd1 vssd1 vccd1 vssd1 X2_sky130_fd_sc_hd__fill_1
X_420_ vccd1 vssd1 vssd1 vccd1 _420_/A _420_/Y _425_/C X2_sky130_fd_sc_hd__nand2_1
XFILLER_14_525 vssd1 vccd1 vccd1 vssd1 X2_sky130_fd_sc_hd__fill_4
X_351_ vccd1 vssd1 vssd1 vccd1 _539_/Q _554_/Q _406_/A X2_sky130_fd_sc_hd__nand2b_1
XFILLER_14_569 vssd1 vccd1 vssd1 vccd1 X2_sky130_ef_sc_hd__decap_40_12
XTAP_TAPCELL_ROW_101_1331 vccd1 vssd1 X2_sky130_fd_sc_hd__tapvpwrvgnd_1
XFILLER_81_57 vssd1 vccd1 vssd1 vccd1 X2_sky130_ef_sc_hd__decap_40_12
XTAP_TAPCELL_ROW_101_1342 vccd1 vssd1 X2_sky130_fd_sc_hd__tapvpwrvgnd_1
X_282_ vssd1 vccd1 vccd1 vssd1 _597_/D hold67/X _289_/S _450_/A1 X2_sky130_fd_sc_hd__mux2_1
XFILLER_5_223 vccd1 vssd1 vccd1 vssd1 X2_sky130_fd_sc_hd__fill_1
XFILLER_30_83 vccd1 vssd1 vccd1 vssd1 X2_sky130_fd_sc_hd__fill_1
XANTENNA_input32_X _446_/A1 vssd1 vccd1 vccd1 vssd1 X2_sky130_fd_sc_hd__diode_2
XFILLER_1_473 vssd1 vccd1 vssd1 vccd1 X2_sky130_ef_sc_hd__decap_40_12
XFILLER_39_81 vssd1 vccd1 vssd1 vccd1 X2_sky130_ef_sc_hd__decap_40_12
XFILLER_37_617 vssd1 vccd1 vccd1 vssd1 X2_sky130_fd_sc_hd__fill_2
XFILLER_64_403 vssd1 vccd1 vccd1 vssd1 X2_sky130_fd_sc_hd__fill_2
XFILLER_49_488 vssd1 vccd1 vssd1 vccd1 X2_sky130_ef_sc_hd__decap_40_12
XFILLER_91_277 vssd1 vccd1 vccd1 vssd1 X2_sky130_fd_sc_hd__fill_2
XFILLER_17_385 vssd1 vccd1 vccd1 vssd1 X2_sky130_fd_sc_hd__fill_4
XFILLER_32_333 vssd1 vccd1 vccd1 vssd1 X2_sky130_fd_sc_hd__fill_2
X_549_ vssd1 vccd1 vccd1 vssd1 _608_/CLK _549_/D _469_/Y _549_/Q X2_sky130_fd_sc_hd__dfrtp_1
XFILLER_44_193 vssd1 vccd1 vccd1 vssd1 X2_sky130_fd_sc_hd__fill_2
XFILLER_32_377 vssd1 vccd1 vccd1 vssd1 X2_sky130_fd_sc_hd__fill_2
XFILLER_32_388 vssd1 vccd1 vssd1 vccd1 X2_sky130_ef_sc_hd__decap_40_12
XTAP_TAPCELL_ROW_30_545 vccd1 vssd1 X2_sky130_fd_sc_hd__tapvpwrvgnd_1
XFILLER_9_573 vssd1 vccd1 vssd1 vccd1 X2_sky130_ef_sc_hd__decap_40_12
XFILLER_72_3 vssd1 vccd1 vssd1 vccd1 X2_sky130_ef_sc_hd__decap_40_12
XFILLER_87_517 vssd1 vccd1 vssd1 vccd1 X2_sky130_ef_sc_hd__decap_40_12
XFILLER_95_561 vssd1 vccd1 vssd1 vccd1 X2_sky130_ef_sc_hd__decap_40_12
XTAP_TAPCELL_ROW_2_237 vccd1 vssd1 X2_sky130_fd_sc_hd__tapvpwrvgnd_1
XFILLER_27_105 vssd1 vccd1 vccd1 vssd1 X2_sky130_fd_sc_hd__fill_4
XFILLER_27_149 vssd1 vccd1 vssd1 vccd1 X2_sky130_ef_sc_hd__decap_40_12
XTAP_TAPCELL_ROW_38_634 vccd1 vssd1 X2_sky130_fd_sc_hd__tapvpwrvgnd_1
XFILLER_82_233 vssd1 vccd1 vssd1 vccd1 X2_sky130_ef_sc_hd__decap_40_12
XTAP_TAPCELL_ROW_66_943 vccd1 vssd1 X2_sky130_fd_sc_hd__tapvpwrvgnd_1
XFILLER_55_447 vccd1 vssd1 vccd1 vssd1 X2_sky130_fd_sc_hd__fill_1
XFILLER_82_277 vssd1 vccd1 vssd1 vccd1 X2_sky130_ef_sc_hd__decap_40_12
XFILLER_70_417 vssd1 vccd1 vccd1 vssd1 X2_sky130_fd_sc_hd__fill_2
XFILLER_23_333 vssd1 vccd1 vccd1 vssd1 X2_sky130_fd_sc_hd__fill_2
XFILLER_50_141 vssd1 vccd1 vssd1 vccd1 X2_sky130_ef_sc_hd__decap_40_12
XFILLER_11_517 vssd1 vccd1 vssd1 vccd1 X2_sky130_ef_sc_hd__decap_40_12
XFILLER_51_27 vssd1 vccd1 vssd1 vccd1 X2_sky130_ef_sc_hd__decap_40_12
XFILLER_19_617 vssd1 vccd1 vccd1 vssd1 X2_sky130_fd_sc_hd__fill_8
XFILLER_58_285 vssd1 vccd1 vccd1 vssd1 X2_sky130_fd_sc_hd__fill_4
XFILLER_58_296 vssd1 vccd1 vssd1 vccd1 X2_sky130_ef_sc_hd__decap_40_12
XFILLER_73_277 vssd1 vccd1 vccd1 vssd1 X2_sky130_fd_sc_hd__fill_2
XFILLER_61_417 vssd1 vccd1 vssd1 vccd1 X2_sky130_ef_sc_hd__decap_40_12
XFILLER_46_469 vssd1 vccd1 vccd1 vssd1 X2_sky130_fd_sc_hd__fill_4
X_403_ vccd1 vssd1 vssd1 vccd1 _555_/Q _422_/A _403_/Y X2_sky130_fd_sc_hd__nor2_1
XFILLER_14_333 vssd1 vccd1 vssd1 vccd1 X2_sky130_ef_sc_hd__decap_40_12
XFILLER_26_193 vssd1 vccd1 vccd1 vssd1 X2_sky130_fd_sc_hd__fill_2
XFILLER_14_377 vssd1 vccd1 vssd1 vccd1 X2_sky130_ef_sc_hd__decap_40_12
X_334_ vccd1 vssd1 vssd1 vccd1 _333_/X _317_/B hold59/X _332_/X _334_/X X2_sky130_fd_sc_hd__o22a_1
X_265_ vccd1 vssd1 vccd1 vssd1 _606_/D _303_/B X2_sky130_fd_sc_hd__inv_2
XFILLER_41_93 vssd1 vccd1 vssd1 vccd1 X2_sky130_ef_sc_hd__decap_40_12
XFILLER_6_587 vccd1 vssd1 vccd1 vssd1 X2_sky130_fd_sc_hd__fill_1
XFILLER_69_517 vssd1 vccd1 vssd1 vccd1 X2_sky130_ef_sc_hd__decap_40_12
XFILLER_1_281 vssd1 vccd1 vssd1 vccd1 X2_sky130_ef_sc_hd__decap_40_12
XPHY_EDGE_ROW_16_Left_118 vccd1 vssd1 vccd1 vssd1 X2_sky130_fd_sc_hd__decap_3
XFILLER_2_65 vssd1 vccd1 vssd1 vccd1 X2_sky130_ef_sc_hd__decap_40_12
XFILLER_77_561 vssd1 vccd1 vssd1 vccd1 X2_sky130_ef_sc_hd__decap_40_12
XFILLER_37_447 vccd1 vssd1 vccd1 vssd1 X2_sky130_fd_sc_hd__fill_1
XFILLER_37_458 vssd1 vccd1 vccd1 vssd1 X2_sky130_fd_sc_hd__fill_2
XFILLER_92_531 vccd1 vssd1 vccd1 vssd1 X2_sky130_fd_sc_hd__fill_1
XFILLER_64_233 vssd1 vccd1 vssd1 vccd1 X2_sky130_ef_sc_hd__decap_40_12
XFILLER_25_609 vssd1 vccd1 vccd1 vssd1 X2_sky130_fd_sc_hd__fill_4
XTAP_TAPCELL_ROW_35_604 vccd1 vssd1 X2_sky130_fd_sc_hd__tapvpwrvgnd_1
XFILLER_64_277 vssd1 vccd1 vccd1 vssd1 X2_sky130_fd_sc_hd__fill_2
XTAP_TAPCELL_ROW_63_913 vccd1 vssd1 X2_sky130_fd_sc_hd__tapvpwrvgnd_1
XFILLER_33_620 vssd1 vccd1 vccd1 vssd1 X2_sky130_fd_sc_hd__fill_2
XFILLER_64_299 vssd1 vccd1 vccd1 vssd1 X2_sky130_fd_sc_hd__fill_4
XFILLER_17_193 vssd1 vccd1 vssd1 vccd1 X2_sky130_ef_sc_hd__decap_40_12
XFILLER_32_141 vssd1 vccd1 vssd1 vccd1 X2_sky130_ef_sc_hd__decap_40_12
XPHY_EDGE_ROW_25_Left_127 vccd1 vssd1 vccd1 vssd1 X2_sky130_fd_sc_hd__decap_3
XTAP_TAPCELL_ROW_15_383 vccd1 vssd1 X2_sky130_fd_sc_hd__tapvpwrvgnd_1
XTAP_TAPCELL_ROW_43_692 vccd1 vssd1 X2_sky130_fd_sc_hd__tapvpwrvgnd_1
XPHY_EDGE_ROW_34_Left_136 vccd1 vssd1 vccd1 vssd1 X2_sky130_fd_sc_hd__decap_3
XFILLER_87_325 vccd1 vssd1 vccd1 vssd1 X2_sky130_fd_sc_hd__fill_1
XFILLER_101_113 vssd1 vccd1 vssd1 vccd1 X2_sky130_ef_sc_hd__decap_40_12
XANTENNA__570__CLK _606_/CLK vssd1 vccd1 vccd1 vssd1 X2_sky130_fd_sc_hd__diode_2
XFILLER_87_358 vssd1 vccd1 vssd1 vccd1 X2_sky130_ef_sc_hd__decap_40_12
XFILLER_95_380 vssd1 vccd1 vccd1 vssd1 X2_sky130_fd_sc_hd__fill_2
XFILLER_46_27 vccd1 vssd1 vccd1 vssd1 X2_sky130_fd_sc_hd__fill_1
XFILLER_28_469 vssd1 vccd1 vccd1 vssd1 X2_sky130_fd_sc_hd__fill_4
XFILLER_83_553 vssd1 vccd1 vccd1 vssd1 X2_sky130_fd_sc_hd__fill_4
XFILLER_55_277 vssd1 vccd1 vccd1 vssd1 X2_sky130_fd_sc_hd__fill_2
XFILLER_36_480 vssd1 vccd1 vccd1 vssd1 X2_sky130_fd_sc_hd__fill_2
XTAP_TAPCELL_ROW_87_1178 vccd1 vssd1 X2_sky130_fd_sc_hd__tapvpwrvgnd_1
XFILLER_83_597 vssd1 vccd1 vssd1 vccd1 X2_sky130_ef_sc_hd__decap_40_12
XFILLER_62_15 vssd1 vccd1 vssd1 vccd1 X2_sky130_ef_sc_hd__decap_40_12
XPHY_EDGE_ROW_43_Left_145 vccd1 vssd1 vccd1 vssd1 X2_sky130_fd_sc_hd__decap_3
XFILLER_51_461 vssd1 vccd1 vssd1 vccd1 X2_sky130_ef_sc_hd__decap_40_12
XFILLER_7_329 vssd1 vccd1 vccd1 vssd1 X2_sky130_fd_sc_hd__fill_4
XTAP_TAPCELL_ROW_98_1296 vccd1 vssd1 X2_sky130_fd_sc_hd__tapvpwrvgnd_1
XFILLER_2_3 vccd1 vssd1 vccd1 vssd1 X2_sky130_fd_sc_hd__fill_1
XFILLER_3_557 vssd1 vccd1 vccd1 vssd1 X2_sky130_fd_sc_hd__fill_2
XPHY_EDGE_ROW_52_Left_154 vccd1 vssd1 vccd1 vssd1 X2_sky130_fd_sc_hd__decap_3
XFILLER_93_328 vssd1 vccd1 vccd1 vssd1 X2_sky130_fd_sc_hd__fill_2
XFILLER_59_561 vssd1 vccd1 vssd1 vccd1 X2_sky130_ef_sc_hd__decap_40_12
XFILLER_46_200 vssd1 vccd1 vccd1 vssd1 X2_sky130_fd_sc_hd__fill_2
XFILLER_19_447 vccd1 vssd1 vccd1 vssd1 X2_sky130_fd_sc_hd__fill_1
XFILLER_74_531 vccd1 vssd1 vccd1 vssd1 X2_sky130_fd_sc_hd__fill_1
XFILLER_46_244 vssd1 vccd1 vccd1 vssd1 X2_sky130_fd_sc_hd__fill_8
XFILLER_61_225 vccd1 vssd1 vccd1 vssd1 X2_sky130_fd_sc_hd__fill_1
XPHY_EDGE_ROW_61_Left_163 vccd1 vssd1 vccd1 vssd1 X2_sky130_fd_sc_hd__decap_3
XFILLER_46_288 vssd1 vccd1 vccd1 vssd1 X2_sky130_fd_sc_hd__fill_2
XFILLER_14_141 vssd1 vccd1 vssd1 vccd1 X2_sky130_ef_sc_hd__decap_40_12
XFILLER_30_601 vssd1 vccd1 vssd1 vccd1 X2_sky130_ef_sc_hd__decap_40_12
XFILLER_42_450 vccd1 vssd1 vccd1 vssd1 X2_sky130_fd_sc_hd__fill_1
X_317_ vssd1 vccd1 _317_/X _317_/B _553_/D _317_/C vccd1 vssd1 X2_sky130_fd_sc_hd__and3_1
XTAP_TAPCELL_ROW_12_353 vccd1 vssd1 X2_sky130_fd_sc_hd__tapvpwrvgnd_1
Xinput13 vssd1 vccd1 wb_rst_i input13/X vccd1 vssd1 X2_sky130_fd_sc_hd__clkbuf_2
XTAP_TAPCELL_ROW_40_662 vccd1 vssd1 X2_sky130_fd_sc_hd__tapvpwrvgnd_1
XFILLER_52_81 vssd1 vccd1 vccd1 vssd1 X2_sky130_fd_sc_hd__fill_2
Xinput35 vssd1 vccd1 wbs_dat_i[6] _449_/A1 vccd1 vssd1 X2_sky130_fd_sc_hd__clkbuf_2
Xinput24 vssd1 vccd1 _279_/A0 wbs_dat_i[10] vccd1 vssd1 X2_sky130_fd_sc_hd__clkbuf_1
XPHY_EDGE_ROW_70_Left_172 vccd1 vssd1 vccd1 vssd1 X2_sky130_fd_sc_hd__decap_3
XFILLER_35_3 vccd1 vssd1 vccd1 vssd1 X2_sky130_fd_sc_hd__fill_1
XFILLER_69_325 vssd1 vccd1 vccd1 vssd1 X2_sky130_fd_sc_hd__fill_2
XFILLER_96_133 vssd1 vccd1 vccd1 vssd1 X2_sky130_fd_sc_hd__fill_4
XFILLER_96_177 vssd1 vccd1 vssd1 vccd1 X2_sky130_ef_sc_hd__decap_40_12
XFILLER_77_391 vccd1 vssd1 vccd1 vssd1 X2_sky130_fd_sc_hd__fill_1
XANTENNA__496__A _527_/A vssd1 vccd1 vccd1 vssd1 X2_sky130_fd_sc_hd__diode_2
XFILLER_37_244 vssd1 vccd1 vccd1 vssd1 X2_sky130_fd_sc_hd__fill_2
XFILLER_92_350 vssd1 vccd1 vssd1 vccd1 X2_sky130_ef_sc_hd__decap_40_12
XFILLER_80_501 vssd1 vccd1 vssd1 vccd1 X2_sky130_ef_sc_hd__decap_40_12
XFILLER_65_575 vssd1 vccd1 vccd1 vssd1 X2_sky130_fd_sc_hd__fill_2
XFILLER_65_553 vssd1 vccd1 vccd1 vssd1 X2_sky130_fd_sc_hd__fill_4
XTAP_TAPCELL_ROW_48_751 vccd1 vssd1 X2_sky130_fd_sc_hd__tapvpwrvgnd_1
XFILLER_16_19 vssd1 vccd1 vccd1 vssd1 X2_sky130_fd_sc_hd__fill_8
XFILLER_25_417 vssd1 vccd1 vssd1 vccd1 X2_sky130_ef_sc_hd__decap_40_12
XFILLER_37_288 vssd1 vccd1 vssd1 vccd1 X2_sky130_ef_sc_hd__decap_40_12
XFILLER_80_545 vssd1 vccd1 vssd1 vccd1 X2_sky130_ef_sc_hd__decap_40_12
XFILLER_33_461 vssd1 vccd1 vssd1 vccd1 X2_sky130_ef_sc_hd__decap_40_12
XFILLER_80_589 vssd1 vccd1 vssd1 vccd1 X2_sky130_ef_sc_hd__decap_40_12
XFILLER_32_29 vssd1 vccd1 vssd1 vccd1 X2_sky130_ef_sc_hd__decap_40_12
XFILLER_20_133 vssd1 vccd1 vccd1 vssd1 X2_sky130_fd_sc_hd__fill_4
XFILLER_20_177 vssd1 vccd1 vssd1 vccd1 X2_sky130_ef_sc_hd__decap_40_12
XFILLER_88_601 vssd1 vccd1 vssd1 vccd1 X2_sky130_ef_sc_hd__decap_40_12
XFILLER_0_505 vssd1 vccd1 vssd1 vccd1 X2_sky130_ef_sc_hd__decap_40_12
XFILLER_87_111 vccd1 vssd1 vccd1 vssd1 X2_sky130_fd_sc_hd__fill_1
XFILLER_57_15 vssd1 vccd1 vssd1 vccd1 X2_sky130_ef_sc_hd__decap_40_12
XFILLER_75_317 vssd1 vccd1 vssd1 vccd1 X2_sky130_ef_sc_hd__decap_40_12
XFILLER_56_531 vccd1 vssd1 vccd1 vssd1 X2_sky130_fd_sc_hd__fill_1
XFILLER_28_233 vssd1 vccd1 vssd1 vccd1 X2_sky130_ef_sc_hd__decap_40_12
XFILLER_90_309 vccd1 vssd1 vccd1 vssd1 X2_sky130_fd_sc_hd__fill_1
XFILLER_71_501 vssd1 vccd1 vccd1 vssd1 X2_sky130_fd_sc_hd__fill_2
XFILLER_16_417 vssd1 vccd1 vccd1 vssd1 X2_sky130_fd_sc_hd__fill_2
XFILLER_83_361 vssd1 vccd1 vssd1 vccd1 X2_sky130_ef_sc_hd__decap_40_12
XFILLER_43_225 vssd1 vccd1 vssd1 vccd1 X2_sky130_ef_sc_hd__decap_40_12
XFILLER_73_69 vssd1 vccd1 vssd1 vccd1 X2_sky130_ef_sc_hd__decap_40_12
XFILLER_12_601 vssd1 vccd1 vssd1 vccd1 X2_sky130_ef_sc_hd__decap_40_12
XFILLER_11_111 vccd1 vssd1 vccd1 vssd1 X2_sky130_fd_sc_hd__fill_1
XFILLER_7_137 vssd1 vccd1 vssd1 vccd1 X2_sky130_ef_sc_hd__decap_40_12
XFILLER_98_77 vssd1 vccd1 vccd1 vssd1 X2_sky130_fd_sc_hd__fill_4
XFILLER_78_133 vssd1 vccd1 vccd1 vssd1 X2_sky130_fd_sc_hd__fill_4
XFILLER_78_177 vssd1 vccd1 vssd1 vccd1 X2_sky130_ef_sc_hd__decap_40_12
XFILLER_93_125 vssd1 vccd1 vssd1 vccd1 X2_sky130_ef_sc_hd__decap_40_12
XFILLER_59_391 vccd1 vssd1 vccd1 vssd1 X2_sky130_fd_sc_hd__fill_1
XFILLER_93_169 vssd1 vccd1 vssd1 vccd1 X2_sky130_ef_sc_hd__decap_40_12
XFILLER_47_553 vssd1 vccd1 vccd1 vssd1 X2_sky130_fd_sc_hd__fill_2
XFILLER_47_81 vssd1 vccd1 vssd1 vccd1 X2_sky130_ef_sc_hd__decap_40_12
XTAP_TAPCELL_ROW_17_412 vccd1 vssd1 X2_sky130_fd_sc_hd__tapvpwrvgnd_1
XFILLER_19_277 vssd1 vccd1 vccd1 vssd1 X2_sky130_fd_sc_hd__fill_2
XFILLER_74_361 vssd1 vccd1 vccd1 vssd1 X2_sky130_fd_sc_hd__fill_2
XANTENNA_clkload5_A _607_/CLK vssd1 vccd1 vccd1 vssd1 X2_sky130_fd_sc_hd__diode_2
XFILLER_62_501 vssd1 vccd1 vssd1 vccd1 X2_sky130_ef_sc_hd__decap_40_12
XFILLER_47_597 vssd1 vccd1 vssd1 vccd1 X2_sky130_ef_sc_hd__decap_40_12
XTAP_TAPCELL_ROW_45_710 vccd1 vssd1 X2_sky130_fd_sc_hd__tapvpwrvgnd_1
XFILLER_62_545 vssd1 vccd1 vssd1 vccd1 X2_sky130_ef_sc_hd__decap_40_12
XFILLER_15_461 vssd1 vccd1 vssd1 vccd1 X2_sky130_ef_sc_hd__decap_40_12
XFILLER_62_589 vccd1 vssd1 vccd1 vssd1 X2_sky130_fd_sc_hd__fill_1
XFILLER_8_53 vssd1 vccd1 vssd1 vccd1 X2_sky130_ef_sc_hd__decap_40_12
XFILLER_30_475 vccd1 vssd1 vccd1 vssd1 X2_sky130_fd_sc_hd__fill_1
XFILLER_8_97 vssd1 vccd1 vssd1 vccd1 X2_sky130_ef_sc_hd__decap_40_12
XTAP_TAPCELL_ROW_73_1019 vccd1 vssd1 X2_sky130_fd_sc_hd__tapvpwrvgnd_1
XFILLER_69_111 vccd1 vssd1 vccd1 vssd1 X2_sky130_fd_sc_hd__fill_1
XFILLER_85_615 vccd1 vssd1 vccd1 vssd1 X2_sky130_fd_sc_hd__fill_1
XFILLER_97_497 vssd1 vccd1 vccd1 vssd1 X2_sky130_fd_sc_hd__fill_4
XFILLER_72_309 vssd1 vccd1 vssd1 vccd1 X2_sky130_ef_sc_hd__decap_40_12
XFILLER_25_225 vssd1 vccd1 vssd1 vccd1 X2_sky130_ef_sc_hd__decap_40_12
XTAP_TAPCELL_ROW_84_1148 vccd1 vssd1 X2_sky130_fd_sc_hd__tapvpwrvgnd_1
XFILLER_53_556 vssd1 vccd1 vccd1 vssd1 X2_sky130_fd_sc_hd__fill_4
XFILLER_43_39 vssd1 vccd1 vssd1 vccd1 X2_sky130_ef_sc_hd__decap_40_12
XTAP_TAPCELL_ROW_51_779 vccd1 vssd1 X2_sky130_fd_sc_hd__tapvpwrvgnd_1
XFILLER_21_497 vssd1 vccd1 vccd1 vssd1 X2_sky130_fd_sc_hd__fill_4
XTAP_TAPCELL_ROW_95_1266 vccd1 vssd1 X2_sky130_fd_sc_hd__tapvpwrvgnd_1
XFILLER_0_324 vccd1 vssd1 vccd1 vssd1 X2_sky130_fd_sc_hd__fill_1
XFILLER_0_335 vccd1 vssd1 vccd1 vssd1 X2_sky130_fd_sc_hd__fill_1
XFILLER_88_475 vccd1 vssd1 vccd1 vssd1 X2_sky130_fd_sc_hd__fill_1
XFILLER_48_306 vssd1 vccd1 vccd1 vssd1 X2_sky130_fd_sc_hd__fill_2
XFILLER_75_125 vssd1 vccd1 vssd1 vccd1 X2_sky130_ef_sc_hd__decap_40_12
XFILLER_29_553 vssd1 vccd1 vccd1 vssd1 X2_sky130_fd_sc_hd__fill_4
XFILLER_75_169 vssd1 vccd1 vssd1 vccd1 X2_sky130_ef_sc_hd__decap_40_12
XFILLER_63_309 vccd1 vssd1 vccd1 vssd1 X2_sky130_fd_sc_hd__fill_1
XTAP_TAPCELL_ROW_59_868 vccd1 vssd1 X2_sky130_fd_sc_hd__tapvpwrvgnd_1
XFILLER_29_597 vssd1 vccd1 vssd1 vccd1 X2_sky130_ef_sc_hd__decap_40_12
XFILLER_44_523 vssd1 vccd1 vccd1 vssd1 X2_sky130_fd_sc_hd__fill_8
X_582_ vssd1 vccd1 vccd1 vssd1 _609_/CLK _582_/D _502_/Y _582_/Q X2_sky130_fd_sc_hd__dfrtp_1
XFILLER_17_51 vssd1 vccd1 vccd1 vssd1 X2_sky130_fd_sc_hd__fill_4
XFILLER_90_139 vccd1 vssd1 vccd1 vssd1 X2_sky130_fd_sc_hd__fill_1
XFILLER_31_217 vssd1 vccd1 vccd1 vssd1 X2_sky130_fd_sc_hd__fill_4
XFILLER_44_589 vssd1 vccd1 vccd1 vssd1 X2_sky130_fd_sc_hd__fill_2
XFILLER_8_413 vssd1 vccd1 vccd1 vssd1 X2_sky130_fd_sc_hd__fill_4
XFILLER_12_475 vccd1 vssd1 vccd1 vssd1 X2_sky130_fd_sc_hd__fill_1
XFILLER_8_457 vssd1 vccd1 vssd1 vccd1 X2_sky130_ef_sc_hd__decap_40_12
XFILLER_94_401 vssd1 vccd1 vssd1 vccd1 X2_sky130_ef_sc_hd__decap_40_12
XFILLER_94_445 vssd1 vccd1 vssd1 vccd1 X2_sky130_ef_sc_hd__decap_40_12
XFILLER_79_497 vssd1 vccd1 vccd1 vssd1 X2_sky130_fd_sc_hd__fill_4
Xhold2 hold2/X hold2/A vccd1 vssd1 vssd1 vccd1 X2_sky130_fd_sc_hd__dlygate4sd3_1
XFILLER_54_309 vssd1 vccd1 vssd1 vccd1 X2_sky130_ef_sc_hd__decap_40_12
XFILLER_94_489 vssd1 vccd1 vssd1 vccd1 X2_sky130_ef_sc_hd__decap_40_12
XFILLER_35_545 vccd1 vssd1 vccd1 vssd1 X2_sky130_fd_sc_hd__fill_1
XFILLER_30_261 vccd1 vssd1 vccd1 vssd1 X2_sky130_fd_sc_hd__fill_1
XFILLER_30_283 vssd1 vccd1 vccd1 vssd1 X2_sky130_fd_sc_hd__fill_2
XFILLER_89_217 vssd1 vccd1 vccd1 vssd1 X2_sky130_fd_sc_hd__fill_4
XFILLER_97_261 vssd1 vccd1 vssd1 vccd1 X2_sky130_ef_sc_hd__decap_40_12
XFILLER_57_125 vssd1 vccd1 vssd1 vccd1 X2_sky130_ef_sc_hd__decap_40_12
XFILLER_85_445 vssd1 vccd1 vccd1 vssd1 X2_sky130_fd_sc_hd__fill_2
XFILLER_57_169 vssd1 vccd1 vssd1 vccd1 X2_sky130_ef_sc_hd__decap_40_12
XFILLER_45_309 vssd1 vccd1 vccd1 vssd1 X2_sky130_fd_sc_hd__fill_2
XFILLER_26_501 vssd1 vccd1 vssd1 vccd1 X2_sky130_ef_sc_hd__decap_40_12
XTAP_TAPCELL_ROW_28_529 vccd1 vssd1 X2_sky130_fd_sc_hd__tapvpwrvgnd_1
XTAP_TAPCELL_ROW_56_838 vccd1 vssd1 X2_sky130_fd_sc_hd__tapvpwrvgnd_1
XFILLER_26_545 vssd1 vccd1 vssd1 vccd1 X2_sky130_ef_sc_hd__decap_40_12
XFILLER_72_139 vccd1 vssd1 vccd1 vssd1 X2_sky130_fd_sc_hd__fill_1
XFILLER_54_27 vccd1 vssd1 vccd1 vssd1 X2_sky130_fd_sc_hd__fill_1
XFILLER_26_589 vssd1 vccd1 vssd1 vccd1 X2_sky130_ef_sc_hd__decap_40_12
XFILLER_13_217 vssd1 vccd1 vccd1 vssd1 X2_sky130_fd_sc_hd__fill_4
XFILLER_53_397 vssd1 vccd1 vssd1 vccd1 X2_sky130_ef_sc_hd__decap_40_12
XFILLER_41_548 vssd1 vccd1 vccd1 vssd1 X2_sky130_fd_sc_hd__fill_2
XFILLER_70_15 vssd1 vccd1 vssd1 vccd1 X2_sky130_ef_sc_hd__decap_40_12
XFILLER_21_261 vssd1 vccd1 vssd1 vccd1 X2_sky130_ef_sc_hd__decap_40_12
XFILLER_5_405 vssd1 vccd1 vssd1 vccd1 X2_sky130_ef_sc_hd__decap_40_12
XFILLER_5_449 vssd1 vccd1 vssd1 vccd1 X2_sky130_ef_sc_hd__decap_40_12
XFILLER_79_57 vssd1 vccd1 vssd1 vccd1 X2_sky130_ef_sc_hd__decap_40_12
XFILLER_76_401 vssd1 vccd1 vssd1 vccd1 X2_sky130_ef_sc_hd__decap_40_12
XFILLER_49_615 vccd1 vssd1 vccd1 vssd1 X2_sky130_fd_sc_hd__fill_1
XFILLER_0_165 vssd1 vccd1 vccd1 vssd1 X2_sky130_fd_sc_hd__fill_2
XFILLER_36_309 vssd1 vccd1 vssd1 vccd1 X2_sky130_ef_sc_hd__decap_40_12
XFILLER_76_445 vssd1 vccd1 vssd1 vccd1 X2_sky130_ef_sc_hd__decap_40_12
XANTENNA_input22_A wbs_cyc_i vssd1 vccd1 vccd1 vssd1 X2_sky130_fd_sc_hd__diode_2
XFILLER_17_501 vssd1 vccd1 vccd1 vssd1 X2_sky130_fd_sc_hd__fill_2
XFILLER_28_83 vccd1 vssd1 vccd1 vssd1 X2_sky130_fd_sc_hd__fill_1
XFILLER_29_361 vssd1 vccd1 vssd1 vccd1 X2_sky130_ef_sc_hd__decap_40_12
XFILLER_76_489 vssd1 vccd1 vssd1 vccd1 X2_sky130_ef_sc_hd__decap_40_12
X_565_ vssd1 vccd1 vccd1 vssd1 _599_/CLK _565_/D _485_/Y _565_/Q X2_sky130_fd_sc_hd__dfrtp_1
XFILLER_71_161 vssd1 vccd1 vccd1 vssd1 X2_sky130_fd_sc_hd__fill_4
X_496_ vccd1 vssd1 vccd1 vssd1 _496_/Y _527_/A X2_sky130_fd_sc_hd__inv_2
XFILLER_8_221 vssd1 vccd1 vssd1 vccd1 X2_sky130_ef_sc_hd__decap_40_12
XFILLER_8_265 vssd1 vccd1 vssd1 vccd1 X2_sky130_ef_sc_hd__decap_40_12
XFILLER_60_81 vssd1 vccd1 vccd1 vssd1 X2_sky130_fd_sc_hd__fill_2
XFILLER_99_559 vccd1 vssd1 vccd1 vssd1 X2_sky130_fd_sc_hd__fill_1
XFILLER_86_209 vssd1 vccd1 vssd1 vccd1 X2_sky130_ef_sc_hd__decap_40_12
XFILLER_39_125 vssd1 vccd1 vssd1 vccd1 X2_sky130_ef_sc_hd__decap_40_12
XFILLER_79_261 vssd1 vccd1 vccd1 vssd1 X2_sky130_fd_sc_hd__fill_8
XFILLER_94_253 vssd1 vccd1 vssd1 vccd1 X2_sky130_ef_sc_hd__decap_40_12
XFILLER_67_445 vssd1 vccd1 vccd1 vssd1 X2_sky130_fd_sc_hd__fill_2
XFILLER_39_169 vssd1 vccd1 vssd1 vccd1 X2_sky130_ef_sc_hd__decap_40_12
XFILLER_94_297 vccd1 vssd1 vccd1 vssd1 X2_sky130_fd_sc_hd__fill_1
XFILLER_54_139 vccd1 vssd1 vccd1 vssd1 X2_sky130_fd_sc_hd__fill_1
XFILLER_35_364 vssd1 vccd1 vccd1 vssd1 X2_sky130_fd_sc_hd__fill_2
XTAP_TAPCELL_ROW_53_808 vccd1 vssd1 X2_sky130_fd_sc_hd__tapvpwrvgnd_1
XTAP_TAPCELL_ROW_81_1107 vccd1 vssd1 X2_sky130_fd_sc_hd__tapvpwrvgnd_1
XFILLER_23_559 vccd1 vssd1 vccd1 vssd1 X2_sky130_fd_sc_hd__fill_1
XFILLER_10_209 vssd1 vccd1 vssd1 vccd1 X2_sky130_ef_sc_hd__decap_40_12
XTAP_TAPCELL_ROW_33_587 vccd1 vssd1 X2_sky130_fd_sc_hd__tapvpwrvgnd_1
XTAP_TAPCELL_ROW_61_896 vccd1 vssd1 X2_sky130_fd_sc_hd__tapvpwrvgnd_1
XFILLER_50_389 vssd1 vccd1 vccd1 vssd1 X2_sky130_fd_sc_hd__fill_4
XFILLER_40_29 vssd1 vccd1 vssd1 vccd1 X2_sky130_ef_sc_hd__decap_40_12
XFILLER_2_419 vccd1 vssd1 vccd1 vssd1 X2_sky130_fd_sc_hd__fill_1
XTAP_TAPCELL_ROW_92_1236 vccd1 vssd1 X2_sky130_fd_sc_hd__tapvpwrvgnd_1
XFILLER_49_27 vssd1 vccd1 vssd1 vccd1 X2_sky130_ef_sc_hd__decap_40_12
XFILLER_98_581 vssd1 vccd1 vccd1 vssd1 X2_sky130_fd_sc_hd__fill_4
XFILLER_58_401 vssd1 vccd1 vssd1 vccd1 X2_sky130_ef_sc_hd__decap_40_12
XTAP_TAPCELL_ROW_5_279 vccd1 vssd1 X2_sky130_fd_sc_hd__tapvpwrvgnd_1
XFILLER_100_531 vccd1 vssd1 vccd1 vssd1 X2_sky130_fd_sc_hd__fill_1
XFILLER_65_15 vssd1 vccd1 vssd1 vccd1 X2_sky130_ef_sc_hd__decap_40_12
XFILLER_58_445 vssd1 vccd1 vssd1 vccd1 X2_sky130_ef_sc_hd__decap_40_12
XFILLER_18_309 vssd1 vccd1 vssd1 vccd1 X2_sky130_ef_sc_hd__decap_40_12
XTAP_TAPCELL_ROW_69_974 vccd1 vssd1 X2_sky130_fd_sc_hd__tapvpwrvgnd_1
XFILLER_58_489 vssd1 vccd1 vssd1 vccd1 X2_sky130_ef_sc_hd__decap_40_12
XFILLER_60_109 vssd1 vccd1 vssd1 vccd1 X2_sky130_ef_sc_hd__decap_40_12
X_350_ vccd1 vssd1 vssd1 vccd1 _356_/A _555_/Q _422_/A _425_/D X2_sky130_fd_sc_hd__o21a_1
XFILLER_53_161 vssd1 vccd1 vccd1 vssd1 X2_sky130_fd_sc_hd__fill_4
XFILLER_41_323 vssd1 vccd1 vssd1 vccd1 X2_sky130_ef_sc_hd__decap_40_12
XFILLER_41_312 vssd1 vccd1 vccd1 vssd1 X2_sky130_fd_sc_hd__fill_2
XTAP_TAPCELL_ROW_101_1332 vccd1 vssd1 X2_sky130_fd_sc_hd__tapvpwrvgnd_1
XFILLER_81_69 vssd1 vccd1 vssd1 vccd1 X2_sky130_ef_sc_hd__decap_40_12
XFILLER_14_41 vssd1 vccd1 vssd1 vccd1 X2_sky130_ef_sc_hd__decap_40_12
X_281_ vssd1 vccd1 vccd1 vssd1 _598_/D hold66/X _289_/S _281_/A0 X2_sky130_fd_sc_hd__mux2_1
XTAP_TAPCELL_ROW_101_1343 vccd1 vssd1 X2_sky130_fd_sc_hd__tapvpwrvgnd_1
XFILLER_14_85 vssd1 vccd1 vssd1 vccd1 X2_sky130_ef_sc_hd__decap_40_12
XFILLER_22_581 vssd1 vccd1 vccd1 vssd1 X2_sky130_fd_sc_hd__fill_4
XFILLER_5_279 vccd1 vssd1 vccd1 vssd1 X2_sky130_fd_sc_hd__fill_1
XFILLER_1_441 vssd1 vccd1 vccd1 vssd1 X2_sky130_fd_sc_hd__fill_4
XFILLER_96_529 vssd1 vccd1 vccd1 vssd1 X2_sky130_fd_sc_hd__fill_2
XFILLER_68_209 vssd1 vccd1 vssd1 vccd1 X2_sky130_ef_sc_hd__decap_40_12
XFILLER_1_485 vssd1 vccd1 vssd1 vccd1 X2_sky130_ef_sc_hd__decap_40_12
XFILLER_39_93 vssd1 vccd1 vssd1 vccd1 X2_sky130_ef_sc_hd__decap_40_12
XFILLER_49_456 vssd1 vccd1 vccd1 vssd1 X2_sky130_fd_sc_hd__fill_2
XFILLER_76_253 vssd1 vccd1 vccd1 vssd1 X2_sky130_fd_sc_hd__fill_4
XFILLER_49_478 vssd1 vccd1 vccd1 vssd1 X2_sky130_fd_sc_hd__fill_2
XFILLER_36_139 vccd1 vssd1 vccd1 vssd1 X2_sky130_fd_sc_hd__fill_1
XFILLER_91_223 vccd1 vssd1 vccd1 vssd1 X2_sky130_fd_sc_hd__fill_1
XFILLER_55_81 vssd1 vccd1 vssd1 vccd1 X2_sky130_ef_sc_hd__decap_40_12
XFILLER_51_109 vssd1 vccd1 vccd1 vssd1 X2_sky130_fd_sc_hd__fill_2
XFILLER_32_301 vssd1 vccd1 vccd1 vssd1 X2_sky130_fd_sc_hd__fill_4
X_548_ vssd1 vccd1 vccd1 vssd1 _553_/CLK hold4/X _468_/Y _548_/Q X2_sky130_fd_sc_hd__dfrtp_1
XFILLER_32_356 vssd1 vccd1 vccd1 vssd1 X2_sky130_fd_sc_hd__fill_8
XFILLER_20_529 vssd1 vccd1 vccd1 vssd1 X2_sky130_fd_sc_hd__fill_2
X_479_ vccd1 vssd1 vccd1 vssd1 _479_/Y _527_/A X2_sky130_fd_sc_hd__inv_2
XFILLER_9_541 vssd1 vccd1 vssd1 vccd1 X2_sky130_ef_sc_hd__decap_40_12
XTAP_TAPCELL_ROW_30_546 vccd1 vssd1 X2_sky130_fd_sc_hd__tapvpwrvgnd_1
XFILLER_9_585 vssd1 vccd1 vssd1 vccd1 X2_sky130_ef_sc_hd__decap_40_12
XFILLER_65_3 vssd1 vccd1 vssd1 vccd1 X2_sky130_ef_sc_hd__decap_40_12
XTAP_TAPCELL_ROW_78_1080 vccd1 vssd1 X2_sky130_fd_sc_hd__tapvpwrvgnd_1
XFILLER_99_323 vssd1 vccd1 vccd1 vssd1 X2_sky130_fd_sc_hd__fill_2
XANTENNA__499__A _527_/A vssd1 vccd1 vccd1 vssd1 X2_sky130_fd_sc_hd__diode_2
XFILLER_99_356 vccd1 vssd1 vccd1 vssd1 X2_sky130_fd_sc_hd__fill_1
XFILLER_87_529 vssd1 vccd1 vssd1 vccd1 X2_sky130_ef_sc_hd__decap_40_12
XTAP_TAPCELL_ROW_2_238 vccd1 vssd1 X2_sky130_fd_sc_hd__tapvpwrvgnd_1
XFILLER_95_573 vssd1 vccd1 vssd1 vccd1 X2_sky130_ef_sc_hd__decap_40_12
XFILLER_67_275 vccd1 vssd1 vccd1 vssd1 X2_sky130_fd_sc_hd__fill_1
XTAP_TAPCELL_ROW_38_635 vccd1 vssd1 X2_sky130_fd_sc_hd__tapvpwrvgnd_1
XTAP_TAPCELL_ROW_66_944 vccd1 vssd1 X2_sky130_fd_sc_hd__tapvpwrvgnd_1
XFILLER_55_437 vssd1 vccd1 vccd1 vssd1 X2_sky130_fd_sc_hd__fill_8
XFILLER_82_245 vssd1 vccd1 vccd1 vssd1 X2_sky130_fd_sc_hd__fill_4
XFILLER_42_109 vssd1 vccd1 vssd1 vccd1 X2_sky130_ef_sc_hd__decap_40_12
XFILLER_35_161 vssd1 vccd1 vccd1 vssd1 X2_sky130_fd_sc_hd__fill_4
XFILLER_82_289 vssd1 vccd1 vssd1 vccd1 X2_sky130_ef_sc_hd__decap_40_12
XFILLER_11_529 vssd1 vccd1 vssd1 vccd1 X2_sky130_ef_sc_hd__decap_40_12
XFILLER_23_389 vssd1 vccd1 vccd1 vssd1 X2_sky130_fd_sc_hd__fill_2
XFILLER_50_153 vssd1 vccd1 vssd1 vccd1 X2_sky130_ef_sc_hd__decap_40_12
XFILLER_51_39 vssd1 vccd1 vssd1 vccd1 X2_sky130_ef_sc_hd__decap_40_12
XFILLER_50_197 vccd1 vssd1 vccd1 vssd1 X2_sky130_fd_sc_hd__fill_1
XFILLER_2_249 vssd1 vccd1 vccd1 vssd1 X2_sky130_fd_sc_hd__fill_2
XFILLER_78_529 vssd1 vccd1 vccd1 vssd1 X2_sky130_fd_sc_hd__fill_2
XFILLER_100_361 vssd1 vccd1 vccd1 vssd1 X2_sky130_fd_sc_hd__fill_2
XFILLER_58_253 vccd1 vssd1 vccd1 vssd1 X2_sky130_fd_sc_hd__fill_1
XFILLER_18_139 vccd1 vssd1 vccd1 vssd1 X2_sky130_fd_sc_hd__fill_1
XFILLER_73_223 vccd1 vssd1 vccd1 vssd1 X2_sky130_fd_sc_hd__fill_1
XFILLER_33_109 vssd1 vccd1 vccd1 vssd1 X2_sky130_fd_sc_hd__fill_2
XFILLER_14_301 vssd1 vccd1 vccd1 vssd1 X2_sky130_fd_sc_hd__fill_4
XFILLER_61_429 vssd1 vccd1 vssd1 vccd1 X2_sky130_ef_sc_hd__decap_40_12
X_402_ vssd1 vccd1 vssd1 vccd1 _402_/X _392_/X _400_/X _381_/X _401_/Y X2_sky130_fd_sc_hd__a211o_1
XFILLER_42_610 vssd1 vccd1 vccd1 vssd1 X2_sky130_fd_sc_hd__fill_2
XFILLER_14_345 vssd1 vccd1 vssd1 vccd1 X2_sky130_ef_sc_hd__decap_40_12
XFILLER_25_51 vssd1 vccd1 vccd1 vssd1 X2_sky130_fd_sc_hd__fill_4
XFILLER_14_389 vssd1 vccd1 vssd1 vccd1 X2_sky130_ef_sc_hd__decap_40_12
X_333_ vccd1 vssd1 vccd1 vssd1 _577_/Q _291_/B _333_/X _317_/C hold4/X _303_/X X2_sky130_fd_sc_hd__a221o_1
XFILLER_41_175 vccd1 vssd1 vccd1 vssd1 X2_sky130_fd_sc_hd__fill_1
X_264_ vccd1 vssd1 vssd1 vccd1 _303_/B _266_/A _266_/C X2_sky130_fd_sc_hd__nand2_2
XFILLER_6_533 vssd1 vccd1 vssd1 vccd1 X2_sky130_ef_sc_hd__decap_40_12
XFILLER_69_529 vssd1 vccd1 vssd1 vccd1 X2_sky130_ef_sc_hd__decap_40_12
XFILLER_1_293 vssd1 vccd1 vssd1 vccd1 X2_sky130_ef_sc_hd__decap_40_12
XFILLER_96_359 vssd1 vccd1 vccd1 vssd1 X2_sky130_fd_sc_hd__fill_2
XFILLER_2_77 vssd1 vccd1 vccd1 vssd1 X2_sky130_fd_sc_hd__fill_4
XFILLER_77_573 vssd1 vccd1 vssd1 vccd1 X2_sky130_ef_sc_hd__decap_40_12
XTAP_TAPCELL_ROW_35_605 vccd1 vssd1 X2_sky130_fd_sc_hd__tapvpwrvgnd_1
XFILLER_64_245 vssd1 vccd1 vccd1 vssd1 X2_sky130_fd_sc_hd__fill_4
XTAP_TAPCELL_ROW_63_914 vccd1 vssd1 X2_sky130_fd_sc_hd__tapvpwrvgnd_1
XFILLER_17_161 vssd1 vccd1 vccd1 vssd1 X2_sky130_fd_sc_hd__fill_4
XFILLER_24_109 vssd1 vccd1 vssd1 vccd1 X2_sky130_ef_sc_hd__decap_40_12
XFILLER_92_587 vccd1 vssd1 vccd1 vssd1 X2_sky130_fd_sc_hd__fill_1
XFILLER_52_418 vssd1 vccd1 vccd1 vssd1 X2_sky130_fd_sc_hd__fill_2
XFILLER_32_153 vssd1 vccd1 vssd1 vccd1 X2_sky130_ef_sc_hd__decap_40_12
XFILLER_60_473 vssd1 vccd1 vccd1 vssd1 X2_sky130_fd_sc_hd__fill_2
XTAP_TAPCELL_ROW_15_384 vccd1 vssd1 X2_sky130_fd_sc_hd__tapvpwrvgnd_1
XFILLER_32_197 vssd1 vccd1 vssd1 vccd1 X2_sky130_ef_sc_hd__decap_40_12
XTAP_TAPCELL_ROW_43_693 vccd1 vssd1 X2_sky130_fd_sc_hd__tapvpwrvgnd_1
XFILLER_9_393 vssd1 vccd1 vssd1 vccd1 X2_sky130_ef_sc_hd__decap_40_12
XFILLER_87_337 vccd1 vssd1 vccd1 vssd1 X2_sky130_fd_sc_hd__fill_1
XFILLER_101_125 vssd1 vccd1 vssd1 vccd1 X2_sky130_ef_sc_hd__decap_40_12
XFILLER_101_169 vssd1 vccd1 vssd1 vccd1 X2_sky130_ef_sc_hd__decap_40_12
XFILLER_68_573 vssd1 vccd1 vccd1 vssd1 X2_sky130_fd_sc_hd__fill_2
XFILLER_55_223 vccd1 vssd1 vccd1 vssd1 X2_sky130_fd_sc_hd__fill_1
XFILLER_15_109 vssd1 vccd1 vccd1 vssd1 X2_sky130_fd_sc_hd__fill_2
XTAP_TAPCELL_ROW_87_1179 vccd1 vssd1 X2_sky130_fd_sc_hd__tapvpwrvgnd_1
XFILLER_62_27 vccd1 vssd1 vccd1 vssd1 X2_sky130_fd_sc_hd__fill_1
XFILLER_51_473 vssd1 vccd1 vssd1 vccd1 X2_sky130_ef_sc_hd__decap_40_12
XFILLER_11_337 vssd1 vccd1 vssd1 vccd1 X2_sky130_ef_sc_hd__decap_40_12
XANTENNA__339__C1 _303_/X vssd1 vccd1 vccd1 vssd1 X2_sky130_fd_sc_hd__diode_2
XFILLER_3_503 vccd1 vssd1 vccd1 vssd1 X2_sky130_fd_sc_hd__fill_1
XTAP_TAPCELL_ROW_98_1297 vccd1 vssd1 X2_sky130_fd_sc_hd__tapvpwrvgnd_1
XFILLER_87_57 vssd1 vccd1 vssd1 vccd1 X2_sky130_ef_sc_hd__decap_40_12
XFILLER_59_573 vssd1 vccd1 vssd1 vccd1 X2_sky130_ef_sc_hd__decap_40_12
XFILLER_74_565 vssd1 vccd1 vccd1 vssd1 X2_sky130_fd_sc_hd__fill_2
XFILLER_34_418 vssd1 vccd1 vccd1 vssd1 X2_sky130_fd_sc_hd__fill_2
XFILLER_34_429 vssd1 vccd1 vccd1 vssd1 X2_sky130_fd_sc_hd__fill_2
XFILLER_74_587 vccd1 vssd1 vccd1 vssd1 X2_sky130_fd_sc_hd__fill_1
XFILLER_36_83 vccd1 vssd1 vccd1 vssd1 X2_sky130_fd_sc_hd__fill_1
XFILLER_14_153 vssd1 vccd1 vssd1 vccd1 X2_sky130_ef_sc_hd__decap_40_12
XFILLER_30_613 vssd1 vccd1 vccd1 vssd1 X2_sky130_fd_sc_hd__fill_2
XFILLER_42_473 vssd1 vccd1 vccd1 vssd1 X2_sky130_fd_sc_hd__fill_2
XFILLER_14_197 vssd1 vccd1 vssd1 vccd1 X2_sky130_ef_sc_hd__decap_40_12
XFILLER_30_624 vccd1 vssd1 vccd1 vssd1 X2_sky130_fd_sc_hd__fill_1
X_316_ vccd1 vssd1 vccd1 vssd1 hold30/X _303_/X _316_/X _304_/X _599_/Q _315_/X X2_sky130_fd_sc_hd__a221o_1
XTAP_TAPCELL_ROW_12_354 vccd1 vssd1 X2_sky130_fd_sc_hd__tapvpwrvgnd_1
XTAP_TAPCELL_ROW_40_663 vccd1 vssd1 X2_sky130_fd_sc_hd__tapvpwrvgnd_1
Xinput25 vssd1 vccd1 _278_/A0 wbs_dat_i[11] vccd1 vssd1 X2_sky130_fd_sc_hd__clkbuf_1
Xinput14 vssd1 vccd1 _269_/B wbs_adr_i[0] vccd1 vssd1 X2_sky130_fd_sc_hd__clkbuf_1
Xinput36 vssd1 vccd1 _450_/A1 wbs_dat_i[7] vccd1 vssd1 X2_sky130_fd_sc_hd__buf_1
XFILLER_6_363 vccd1 vssd1 vccd1 vssd1 X2_sky130_fd_sc_hd__fill_1
XTAP_TAPCELL_ROW_75_1050 vccd1 vssd1 X2_sky130_fd_sc_hd__tapvpwrvgnd_1
XFILLER_97_613 vssd1 vccd1 vccd1 vssd1 X2_sky130_fd_sc_hd__fill_2
XFILLER_69_337 vssd1 vccd1 vssd1 vccd1 X2_sky130_ef_sc_hd__decap_40_12
XFILLER_28_3 vssd1 vccd1 vssd1 vccd1 X2_sky130_ef_sc_hd__decap_40_12
XFILLER_37_223 vccd1 vssd1 vccd1 vssd1 X2_sky130_fd_sc_hd__fill_1
XFILLER_96_189 vssd1 vccd1 vccd1 vssd1 X2_sky130_fd_sc_hd__fill_4
XTAP_TAPCELL_ROW_48_752 vccd1 vssd1 X2_sky130_fd_sc_hd__tapvpwrvgnd_1
XFILLER_25_429 vssd1 vccd1 vssd1 vccd1 X2_sky130_ef_sc_hd__decap_40_12
XFILLER_92_362 vssd1 vccd1 vccd1 vssd1 X2_sky130_fd_sc_hd__fill_2
XFILLER_80_513 vssd1 vccd1 vssd1 vccd1 X2_sky130_ef_sc_hd__decap_40_12
XFILLER_52_215 vssd1 vccd1 vccd1 vssd1 X2_sky130_fd_sc_hd__fill_2
XFILLER_80_557 vssd1 vccd1 vssd1 vccd1 X2_sky130_ef_sc_hd__decap_40_12
XFILLER_52_237 vssd1 vccd1 vccd1 vssd1 X2_sky130_fd_sc_hd__fill_2
XFILLER_21_613 vssd1 vccd1 vccd1 vssd1 X2_sky130_fd_sc_hd__fill_2
XFILLER_33_473 vssd1 vccd1 vssd1 vccd1 X2_sky130_ef_sc_hd__decap_40_12
XFILLER_20_189 vssd1 vccd1 vccd1 vssd1 X2_sky130_fd_sc_hd__fill_4
XANTENNA__336__A2 _304_/A vssd1 vccd1 vccd1 vssd1 X2_sky130_fd_sc_hd__diode_2
XANTENNA__304__X _304_/X vssd1 vccd1 vccd1 vssd1 X2_sky130_fd_sc_hd__diode_2
XFILLER_0_517 vssd1 vccd1 vccd1 vssd1 X2_sky130_fd_sc_hd__fill_4
XFILLER_88_613 vssd1 vccd1 vssd1 vccd1 X2_sky130_ef_sc_hd__decap_40_12
XFILLER_87_167 vccd1 vssd1 vccd1 vssd1 X2_sky130_fd_sc_hd__fill_1
XFILLER_57_27 vssd1 vccd1 vssd1 vccd1 X2_sky130_ef_sc_hd__decap_40_12
XFILLER_75_329 vssd1 vccd1 vccd1 vssd1 X2_sky130_fd_sc_hd__fill_4
XFILLER_28_245 vssd1 vccd1 vccd1 vssd1 X2_sky130_fd_sc_hd__fill_4
XFILLER_83_373 vssd1 vccd1 vssd1 vccd1 X2_sky130_ef_sc_hd__decap_40_12
XFILLER_73_15 vssd1 vccd1 vssd1 vccd1 X2_sky130_ef_sc_hd__decap_40_12
XFILLER_56_587 vccd1 vssd1 vccd1 vssd1 X2_sky130_fd_sc_hd__fill_1
XFILLER_71_557 vssd1 vccd1 vccd1 vssd1 X2_sky130_fd_sc_hd__fill_2
XFILLER_43_237 vssd1 vccd1 vssd1 vccd1 X2_sky130_ef_sc_hd__decap_40_12
XFILLER_12_613 vssd1 vccd1 vssd1 vccd1 X2_sky130_ef_sc_hd__decap_40_12
XFILLER_24_473 vssd1 vccd1 vccd1 vssd1 X2_sky130_fd_sc_hd__fill_2
XFILLER_51_281 vssd1 vccd1 vssd1 vccd1 X2_sky130_ef_sc_hd__decap_40_12
XFILLER_7_105 vssd1 vccd1 vccd1 vssd1 X2_sky130_fd_sc_hd__fill_4
XFILLER_11_167 vccd1 vssd1 vccd1 vssd1 X2_sky130_fd_sc_hd__fill_1
XFILLER_22_41 vssd1 vccd1 vssd1 vccd1 X2_sky130_ef_sc_hd__decap_40_12
XANTENNA__327__A2 _304_/A vssd1 vccd1 vccd1 vssd1 X2_sky130_fd_sc_hd__diode_2
XFILLER_7_149 vssd1 vccd1 vssd1 vccd1 X2_sky130_ef_sc_hd__decap_40_12
XFILLER_22_85 vssd1 vccd1 vssd1 vccd1 X2_sky130_ef_sc_hd__decap_40_12
XFILLER_3_333 vssd1 vccd1 vccd1 vssd1 X2_sky130_fd_sc_hd__fill_2
XFILLER_79_613 vssd1 vccd1 vccd1 vssd1 X2_sky130_fd_sc_hd__fill_2
XFILLER_66_307 vccd1 vssd1 vccd1 vssd1 X2_sky130_fd_sc_hd__fill_1
XFILLER_19_223 vccd1 vssd1 vccd1 vssd1 X2_sky130_fd_sc_hd__fill_1
XFILLER_93_137 vssd1 vccd1 vssd1 vccd1 X2_sky130_ef_sc_hd__decap_40_12
XFILLER_78_189 vssd1 vccd1 vccd1 vssd1 X2_sky130_fd_sc_hd__fill_4
XTAP_TAPCELL_ROW_17_402 vccd1 vssd1 X2_sky130_fd_sc_hd__tapvpwrvgnd_1
XFILLER_62_513 vssd1 vccd1 vssd1 vccd1 X2_sky130_ef_sc_hd__decap_40_12
XFILLER_47_93 vssd1 vccd1 vssd1 vccd1 X2_sky130_ef_sc_hd__decap_40_12
XTAP_TAPCELL_ROW_45_711 vccd1 vssd1 X2_sky130_fd_sc_hd__tapvpwrvgnd_1
XFILLER_34_226 vccd1 vssd1 vccd1 vssd1 X2_sky130_fd_sc_hd__fill_1
XFILLER_62_557 vssd1 vccd1 vccd1 vssd1 X2_sky130_fd_sc_hd__fill_4
XFILLER_15_473 vssd1 vccd1 vssd1 vccd1 X2_sky130_ef_sc_hd__decap_40_12
XFILLER_30_421 vssd1 vccd1 vssd1 vccd1 X2_sky130_ef_sc_hd__decap_40_12
XFILLER_63_81 vssd1 vccd1 vssd1 vccd1 X2_sky130_ef_sc_hd__decap_40_12
XTAP_TAPCELL_ROW_25_490 vccd1 vssd1 X2_sky130_fd_sc_hd__tapvpwrvgnd_1
XFILLER_8_65 vssd1 vccd1 vssd1 vccd1 X2_sky130_ef_sc_hd__decap_40_12
XANTENNA__318__A2 _303_/X vssd1 vccd1 vccd1 vssd1 X2_sky130_fd_sc_hd__diode_2
XFILLER_6_193 vssd1 vccd1 vccd1 vssd1 X2_sky130_fd_sc_hd__fill_2
XFILLER_97_432 vssd1 vccd1 vccd1 vssd1 X2_sky130_fd_sc_hd__fill_2
Xtop_soc_80 wbs_dat_o[28] top_soc_80/HI vccd1 vssd1 vssd1 vccd1 X2_sky130_fd_sc_hd__conb_1
XFILLER_69_167 vccd1 vssd1 vccd1 vssd1 X2_sky130_fd_sc_hd__fill_1
XFILLER_57_318 vssd1 vccd1 vssd1 vccd1 X2_sky130_ef_sc_hd__decap_40_12
XFILLER_38_510 vccd1 vssd1 vccd1 vssd1 X2_sky130_fd_sc_hd__fill_1
XFILLER_84_137 vssd1 vccd1 vccd1 vssd1 X2_sky130_fd_sc_hd__fill_2
XFILLER_38_587 vccd1 vssd1 vccd1 vssd1 X2_sky130_fd_sc_hd__fill_1
XFILLER_25_237 vssd1 vccd1 vssd1 vccd1 X2_sky130_ef_sc_hd__decap_40_12
XTAP_TAPCELL_ROW_84_1149 vccd1 vssd1 X2_sky130_fd_sc_hd__tapvpwrvgnd_1
XFILLER_80_321 vssd1 vccd1 vssd1 vccd1 X2_sky130_ef_sc_hd__decap_40_12
XFILLER_80_365 vssd1 vccd1 vssd1 vccd1 X2_sky130_ef_sc_hd__decap_40_12
XFILLER_33_281 vccd1 vssd1 vccd1 vssd1 X2_sky130_fd_sc_hd__fill_1
XFILLER_5_609 vssd1 vccd1 vccd1 vssd1 X2_sky130_fd_sc_hd__fill_4
XTAP_TAPCELL_ROW_95_1267 vccd1 vssd1 X2_sky130_fd_sc_hd__tapvpwrvgnd_1
XFILLER_68_15 vssd1 vccd1 vssd1 vccd1 X2_sky130_ef_sc_hd__decap_40_12
XFILLER_88_421 vssd1 vccd1 vssd1 vccd1 X2_sky130_ef_sc_hd__decap_40_12
XFILLER_75_137 vssd1 vccd1 vssd1 vccd1 X2_sky130_ef_sc_hd__decap_40_12
XTAP_TAPCELL_ROW_59_869 vccd1 vssd1 X2_sky130_fd_sc_hd__tapvpwrvgnd_1
XFILLER_56_362 vssd1 vccd1 vccd1 vssd1 X2_sky130_fd_sc_hd__fill_2
X_581_ vccd1 vssd1 vccd1 vssd1 _581_/Q _501_/Y _581_/D _597_/CLK X2_sky130_fd_sc_hd__dfstp_1
XFILLER_83_181 vssd1 vccd1 vssd1 vccd1 X2_sky130_ef_sc_hd__decap_40_12
XFILLER_12_421 vssd1 vccd1 vssd1 vccd1 X2_sky130_ef_sc_hd__decap_40_12
XFILLER_33_51 vssd1 vccd1 vccd1 vssd1 X2_sky130_fd_sc_hd__fill_4
XTAP_TAPCELL_ROW_22_460 vccd1 vssd1 X2_sky130_fd_sc_hd__tapvpwrvgnd_1
XFILLER_8_469 vssd1 vccd1 vccd1 vssd1 X2_sky130_fd_sc_hd__fill_4
XFILLER_94_413 vssd1 vccd1 vccd1 vssd1 X2_sky130_fd_sc_hd__fill_4
XFILLER_58_81 vssd1 vccd1 vccd1 vssd1 X2_sky130_fd_sc_hd__fill_2
Xhold3 hold3/X hold3/A vccd1 vssd1 vssd1 vccd1 X2_sky130_fd_sc_hd__dlygate4sd3_1
XFILLER_94_457 vssd1 vccd1 vssd1 vccd1 X2_sky130_ef_sc_hd__decap_40_12
XFILLER_66_137 vssd1 vccd1 vccd1 vssd1 X2_sky130_fd_sc_hd__fill_2
XFILLER_35_502 vssd1 vccd1 vccd1 vssd1 X2_sky130_fd_sc_hd__fill_2
XFILLER_62_321 vssd1 vccd1 vssd1 vccd1 X2_sky130_ef_sc_hd__decap_40_12
XFILLER_35_568 vssd1 vccd1 vssd1 vccd1 X2_sky130_ef_sc_hd__decap_40_12
XFILLER_62_365 vssd1 vccd1 vssd1 vccd1 X2_sky130_ef_sc_hd__decap_40_12
XFILLER_95_3 vssd1 vccd1 vssd1 vccd1 X2_sky130_ef_sc_hd__decap_40_12
XFILLER_15_281 vssd1 vccd1 vssd1 vccd1 X2_sky130_ef_sc_hd__decap_40_12
XFILLER_30_251 vccd1 vssd1 vccd1 vssd1 X2_sky130_fd_sc_hd__fill_1
XFILLER_38_29 vssd1 vccd1 vssd1 vccd1 X2_sky130_ef_sc_hd__decap_40_12
XFILLER_97_273 vssd1 vccd1 vccd1 vssd1 X2_sky130_fd_sc_hd__fill_4
XFILLER_38_340 vssd1 vccd1 vssd1 vccd1 X2_sky130_ef_sc_hd__decap_40_12
XFILLER_57_137 vssd1 vccd1 vssd1 vccd1 X2_sky130_ef_sc_hd__decap_40_12
XFILLER_26_513 vssd1 vccd1 vssd1 vccd1 X2_sky130_ef_sc_hd__decap_40_12
XTAP_TAPCELL_ROW_56_839 vccd1 vssd1 X2_sky130_fd_sc_hd__tapvpwrvgnd_1
XFILLER_65_181 vssd1 vccd1 vssd1 vccd1 X2_sky130_ef_sc_hd__decap_40_12
XFILLER_26_557 vssd1 vccd1 vssd1 vccd1 X2_sky130_ef_sc_hd__decap_40_12
XFILLER_41_505 vssd1 vccd1 vssd1 vccd1 X2_sky130_ef_sc_hd__decap_40_12
XFILLER_41_527 vccd1 vssd1 vccd1 vssd1 X2_sky130_fd_sc_hd__fill_1
XFILLER_80_195 vccd1 vssd1 vccd1 vssd1 X2_sky130_fd_sc_hd__fill_1
XFILLER_21_273 vssd1 vccd1 vccd1 vssd1 X2_sky130_fd_sc_hd__fill_4
XFILLER_70_27 vccd1 vssd1 vccd1 vssd1 X2_sky130_fd_sc_hd__fill_1
XFILLER_5_417 vssd1 vccd1 vssd1 vccd1 X2_sky130_ef_sc_hd__decap_40_12
XFILLER_79_69 vssd1 vccd1 vssd1 vccd1 X2_sky130_ef_sc_hd__decap_40_12
XFILLER_0_111 vccd1 vssd1 vccd1 vssd1 X2_sky130_fd_sc_hd__fill_1
XFILLER_0_133 vssd1 vccd1 vccd1 vssd1 X2_sky130_fd_sc_hd__fill_2
XFILLER_88_251 vccd1 vssd1 vccd1 vssd1 X2_sky130_fd_sc_hd__fill_1
XFILLER_95_57 vssd1 vccd1 vssd1 vccd1 X2_sky130_ef_sc_hd__decap_40_12
XFILLER_76_413 vssd1 vccd1 vccd1 vssd1 X2_sky130_fd_sc_hd__fill_4
XFILLER_76_457 vssd1 vccd1 vssd1 vccd1 X2_sky130_ef_sc_hd__decap_40_12
XFILLER_48_137 vssd1 vccd1 vccd1 vssd1 X2_sky130_fd_sc_hd__fill_2
XFILLER_29_373 vssd1 vccd1 vssd1 vccd1 X2_sky130_ef_sc_hd__decap_40_12
XFILLER_91_405 vssd1 vccd1 vssd1 vccd1 X2_sky130_ef_sc_hd__decap_40_12
XANTENNA_input15_A wbs_adr_i[1] vssd1 vccd1 vccd1 vssd1 X2_sky130_fd_sc_hd__diode_2
XFILLER_91_449 vssd1 vccd1 vssd1 vccd1 X2_sky130_ef_sc_hd__decap_40_12
XFILLER_44_321 vssd1 vccd1 vssd1 vccd1 X2_sky130_ef_sc_hd__decap_40_12
XFILLER_17_557 vssd1 vccd1 vccd1 vssd1 X2_sky130_fd_sc_hd__fill_2
XFILLER_44_365 vssd1 vccd1 vssd1 vccd1 X2_sky130_ef_sc_hd__decap_40_12
X_564_ vssd1 vccd1 vccd1 vssd1 _597_/CLK _564_/D _484_/Y _564_/Q X2_sky130_fd_sc_hd__dfrtp_1
X_495_ vccd1 vssd1 vccd1 vssd1 _495_/Y _529_/A X2_sky130_fd_sc_hd__inv_2
XFILLER_44_83 vccd1 vssd1 vccd1 vssd1 X2_sky130_fd_sc_hd__fill_1
XFILLER_12_251 vccd1 vssd1 vccd1 vssd1 X2_sky130_fd_sc_hd__fill_1
XFILLER_8_233 vssd1 vccd1 vssd1 vccd1 X2_sky130_ef_sc_hd__decap_40_12
XFILLER_8_277 vssd1 vccd1 vssd1 vccd1 X2_sky130_ef_sc_hd__decap_40_12
XFILLER_67_7 vssd1 vccd1 vccd1 vssd1 X2_sky130_fd_sc_hd__fill_2
XFILLER_5_55 vccd1 vssd1 vccd1 vssd1 X2_sky130_fd_sc_hd__fill_1
XFILLER_99_505 vssd1 vccd1 vssd1 vccd1 X2_sky130_ef_sc_hd__decap_40_12
XFILLER_10_3 vssd1 vccd1 vssd1 vccd1 X2_sky130_ef_sc_hd__decap_40_12
XFILLER_39_137 vssd1 vccd1 vssd1 vccd1 X2_sky130_ef_sc_hd__decap_40_12
XFILLER_94_221 vssd1 vccd1 vssd1 vccd1 X2_sky130_ef_sc_hd__decap_40_12
XANTENNA__558__Q _558_/Q vssd1 vccd1 vccd1 vssd1 X2_sky130_fd_sc_hd__diode_2
XFILLER_94_265 vssd1 vccd1 vssd1 vccd1 X2_sky130_ef_sc_hd__decap_40_12
XFILLER_35_310 vssd1 vccd1 vccd1 vssd1 X2_sky130_fd_sc_hd__fill_8
XFILLER_23_505 vssd1 vccd1 vssd1 vccd1 X2_sky130_ef_sc_hd__decap_40_12
XTAP_TAPCELL_ROW_81_1108 vccd1 vssd1 X2_sky130_fd_sc_hd__tapvpwrvgnd_1
XFILLER_50_313 vssd1 vccd1 vccd1 vssd1 X2_sky130_fd_sc_hd__fill_2
XFILLER_62_195 vccd1 vssd1 vccd1 vssd1 X2_sky130_fd_sc_hd__fill_1
XFILLER_31_571 vccd1 vssd1 vccd1 vssd1 X2_sky130_fd_sc_hd__fill_1
XTAP_TAPCELL_ROW_33_588 vccd1 vssd1 X2_sky130_fd_sc_hd__tapvpwrvgnd_1
XTAP_TAPCELL_ROW_61_886 vccd1 vssd1 X2_sky130_fd_sc_hd__tapvpwrvgnd_1
XFILLER_31_593 vssd1 vccd1 vssd1 vccd1 X2_sky130_ef_sc_hd__decap_40_12
XTAP_TAPCELL_ROW_92_1237 vccd1 vssd1 X2_sky130_fd_sc_hd__tapvpwrvgnd_1
XANTENNA__448__A1 _448_/A1 vssd1 vccd1 vccd1 vssd1 X2_sky130_fd_sc_hd__diode_2
XFILLER_49_39 vssd1 vccd1 vssd1 vccd1 X2_sky130_ef_sc_hd__decap_40_12
XANTENNA_input7_A adc_data_in[4] vssd1 vccd1 vccd1 vssd1 X2_sky130_fd_sc_hd__diode_2
XFILLER_58_413 vssd1 vccd1 vccd1 vssd1 X2_sky130_fd_sc_hd__fill_4
XFILLER_85_221 vssd1 vccd1 vccd1 vssd1 X2_sky130_fd_sc_hd__fill_2
XFILLER_58_457 vssd1 vccd1 vssd1 vccd1 X2_sky130_ef_sc_hd__decap_40_12
XFILLER_100_587 vccd1 vssd1 vccd1 vssd1 X2_sky130_fd_sc_hd__fill_1
XFILLER_73_405 vssd1 vccd1 vssd1 vccd1 X2_sky130_ef_sc_hd__decap_40_12
XTAP_TAPCELL_ROW_69_975 vccd1 vssd1 X2_sky130_fd_sc_hd__tapvpwrvgnd_1
XFILLER_65_27 vssd1 vccd1 vssd1 vccd1 X2_sky130_ef_sc_hd__decap_40_12
XFILLER_26_321 vssd1 vccd1 vssd1 vccd1 X2_sky130_ef_sc_hd__decap_40_12
XFILLER_73_449 vssd1 vccd1 vssd1 vccd1 X2_sky130_ef_sc_hd__decap_40_12
XFILLER_26_365 vssd1 vccd1 vssd1 vccd1 X2_sky130_ef_sc_hd__decap_40_12
XFILLER_81_15 vssd1 vccd1 vssd1 vccd1 X2_sky130_ef_sc_hd__decap_40_12
X_280_ vssd1 vccd1 vccd1 vssd1 _599_/D hold69/X _289_/S _280_/A0 X2_sky130_fd_sc_hd__mux2_1
XFILLER_41_335 vccd1 vssd1 vccd1 vssd1 X2_sky130_fd_sc_hd__fill_1
XFILLER_14_53 vssd1 vccd1 vssd1 vccd1 X2_sky130_ef_sc_hd__decap_40_12
XTAP_TAPCELL_ROW_101_1344 vccd1 vssd1 X2_sky130_fd_sc_hd__tapvpwrvgnd_1
XTAP_TAPCELL_ROW_101_1333 vccd1 vssd1 X2_sky130_fd_sc_hd__tapvpwrvgnd_1
XFILLER_41_368 vssd1 vccd1 vccd1 vssd1 X2_sky130_fd_sc_hd__fill_2
XFILLER_14_97 vssd1 vccd1 vssd1 vccd1 X2_sky130_ef_sc_hd__decap_40_12
XFILLER_5_225 vssd1 vccd1 vssd1 vccd1 X2_sky130_ef_sc_hd__decap_40_12
XFILLER_30_41 vssd1 vccd1 vssd1 vccd1 X2_sky130_ef_sc_hd__decap_40_12
XFILLER_30_85 vssd1 vccd1 vssd1 vccd1 X2_sky130_ef_sc_hd__decap_40_12
XFILLER_1_497 vssd1 vccd1 vccd1 vssd1 X2_sky130_fd_sc_hd__fill_4
XFILLER_76_221 vssd1 vccd1 vssd1 vccd1 X2_sky130_ef_sc_hd__decap_40_12
XFILLER_49_446 vssd1 vccd1 vccd1 vssd1 X2_sky130_fd_sc_hd__fill_2
XFILLER_37_619 vccd1 vssd1 vccd1 vssd1 X2_sky130_fd_sc_hd__fill_1
XFILLER_29_181 vssd1 vccd1 vssd1 vccd1 X2_sky130_ef_sc_hd__decap_40_12
XPHY_EDGE_ROW_101_Right_101 vccd1 vssd1 vccd1 vssd1 X2_sky130_fd_sc_hd__decap_3
XFILLER_91_279 vccd1 vssd1 vccd1 vssd1 X2_sky130_fd_sc_hd__fill_1
X_547_ vssd1 vccd1 vccd1 vssd1 _553_/CLK _547_/D _467_/Y _547_/Q X2_sky130_fd_sc_hd__dfrtp_1
XFILLER_60_622 vssd1 vccd1 vccd1 vssd1 X2_sky130_fd_sc_hd__fill_2
XFILLER_60_600 vssd1 vccd1 vccd1 vssd1 X2_sky130_fd_sc_hd__fill_2
XFILLER_55_93 vssd1 vccd1 vssd1 vccd1 X2_sky130_ef_sc_hd__decap_40_12
XFILLER_32_335 vccd1 vssd1 vccd1 vssd1 X2_sky130_fd_sc_hd__fill_1
XFILLER_44_195 vccd1 vssd1 vccd1 vssd1 X2_sky130_fd_sc_hd__fill_1
XFILLER_32_379 vccd1 vssd1 vccd1 vssd1 X2_sky130_fd_sc_hd__fill_1
X_478_ vccd1 vssd1 vccd1 vssd1 _478_/Y _529_/A X2_sky130_fd_sc_hd__inv_2
XFILLER_9_553 vssd1 vccd1 vccd1 vssd1 X2_sky130_fd_sc_hd__fill_4
XFILLER_71_81 vssd1 vccd1 vssd1 vccd1 X2_sky130_ef_sc_hd__decap_40_12
XTAP_TAPCELL_ROW_30_547 vccd1 vssd1 X2_sky130_fd_sc_hd__tapvpwrvgnd_1
XFILLER_9_597 vssd1 vccd1 vssd1 vccd1 X2_sky130_ef_sc_hd__decap_40_12
XFILLER_58_3 vssd1 vccd1 vssd1 vccd1 X2_sky130_ef_sc_hd__decap_40_12
XFILLER_99_335 vccd1 vssd1 vccd1 vssd1 X2_sky130_fd_sc_hd__fill_1
XTAP_TAPCELL_ROW_78_1081 vccd1 vssd1 X2_sky130_fd_sc_hd__tapvpwrvgnd_1
XFILLER_99_346 vssd1 vccd1 vccd1 vssd1 X2_sky130_fd_sc_hd__fill_2
XFILLER_101_329 vssd1 vccd1 vccd1 vssd1 X2_sky130_fd_sc_hd__fill_2
XFILLER_95_541 vssd1 vccd1 vssd1 vccd1 X2_sky130_ef_sc_hd__decap_40_12
XFILLER_67_221 vssd1 vccd1 vccd1 vssd1 X2_sky130_fd_sc_hd__fill_2
XFILLER_95_585 vssd1 vccd1 vssd1 vccd1 X2_sky130_ef_sc_hd__decap_40_12
XFILLER_55_405 vssd1 vccd1 vssd1 vccd1 X2_sky130_ef_sc_hd__decap_40_12
XTAP_TAPCELL_ROW_2_239 vccd1 vssd1 X2_sky130_fd_sc_hd__tapvpwrvgnd_1
XTAP_TAPCELL_ROW_38_636 vccd1 vssd1 X2_sky130_fd_sc_hd__tapvpwrvgnd_1
XTAP_TAPCELL_ROW_66_945 vccd1 vssd1 X2_sky130_fd_sc_hd__tapvpwrvgnd_1
XFILLER_55_449 vssd1 vccd1 vssd1 vccd1 X2_sky130_ef_sc_hd__decap_40_12
XFILLER_70_419 vccd1 vssd1 vccd1 vssd1 X2_sky130_fd_sc_hd__fill_1
XFILLER_23_335 vccd1 vssd1 vccd1 vssd1 X2_sky130_fd_sc_hd__fill_1
XFILLER_50_121 vssd1 vccd1 vssd1 vccd1 X2_sky130_ef_sc_hd__decap_40_12
XFILLER_50_165 vssd1 vccd1 vssd1 vccd1 X2_sky130_ef_sc_hd__decap_40_12
XFILLER_31_390 vssd1 vccd1 vccd1 vssd1 X2_sky130_fd_sc_hd__fill_2
XFILLER_76_15 vssd1 vccd1 vssd1 vccd1 X2_sky130_ef_sc_hd__decap_40_12
XFILLER_58_221 vssd1 vccd1 vssd1 vccd1 X2_sky130_ef_sc_hd__decap_40_12
XANTENNA_fanout65_A input13/X vssd1 vccd1 vccd1 vssd1 X2_sky130_fd_sc_hd__diode_2
XFILLER_86_585 vssd1 vccd1 vccd1 vssd1 X2_sky130_fd_sc_hd__fill_2
XFILLER_73_279 vccd1 vssd1 vccd1 vssd1 X2_sky130_fd_sc_hd__fill_1
X_401_ vssd1 vccd1 _406_/C _401_/Y _425_/B vccd1 vssd1 X2_sky130_fd_sc_hd__xnor2_1
XFILLER_26_195 vccd1 vssd1 vccd1 vssd1 X2_sky130_fd_sc_hd__fill_1
XFILLER_14_357 vssd1 vccd1 vccd1 vssd1 X2_sky130_fd_sc_hd__fill_4
X_332_ vccd1 vssd1 vccd1 vssd1 _320_/X hold24/X _304_/A _332_/X hold45/X X2_sky130_fd_sc_hd__a22o_1
XFILLER_41_165 vssd1 vccd1 vccd1 vssd1 X2_sky130_fd_sc_hd__fill_2
X_263_ vccd1 vssd1 vccd1 vssd1 _263_/Y _473_/A X2_sky130_fd_sc_hd__inv_2
XFILLER_6_501 vssd1 vccd1 vssd1 vccd1 X2_sky130_ef_sc_hd__decap_40_12
XFILLER_6_545 vssd1 vccd1 vssd1 vccd1 X2_sky130_ef_sc_hd__decap_40_12
XFILLER_10_585 vssd1 vccd1 vccd1 vssd1 X2_sky130_fd_sc_hd__fill_2
XFILLER_41_51 vssd1 vccd1 vccd1 vssd1 X2_sky130_fd_sc_hd__fill_4
XFILLER_6_589 vssd1 vccd1 vssd1 vccd1 X2_sky130_ef_sc_hd__decap_40_12
XFILLER_1_261 vssd1 vccd1 vccd1 vssd1 X2_sky130_fd_sc_hd__fill_4
XFILLER_96_327 vssd1 vccd1 vccd1 vssd1 X2_sky130_fd_sc_hd__fill_2
XFILLER_96_349 vssd1 vccd1 vccd1 vssd1 X2_sky130_fd_sc_hd__fill_2
XFILLER_77_541 vssd1 vccd1 vssd1 vccd1 X2_sky130_ef_sc_hd__decap_40_12
XFILLER_37_427 vssd1 vccd1 vccd1 vssd1 X2_sky130_fd_sc_hd__fill_4
XFILLER_37_449 vssd1 vccd1 vccd1 vssd1 X2_sky130_fd_sc_hd__fill_4
XFILLER_92_533 vssd1 vccd1 vssd1 vccd1 X2_sky130_ef_sc_hd__decap_40_12
XFILLER_77_585 vssd1 vccd1 vssd1 vccd1 X2_sky130_ef_sc_hd__decap_40_12
XFILLER_66_81 vssd1 vccd1 vccd1 vssd1 X2_sky130_fd_sc_hd__fill_2
XFILLER_33_600 vccd1 vssd1 vccd1 vssd1 X2_sky130_fd_sc_hd__fill_1
XTAP_TAPCELL_ROW_35_606 vccd1 vssd1 X2_sky130_fd_sc_hd__tapvpwrvgnd_1
XTAP_TAPCELL_ROW_63_915 vccd1 vssd1 X2_sky130_fd_sc_hd__tapvpwrvgnd_1
XFILLER_32_121 vssd1 vccd1 vssd1 vccd1 X2_sky130_ef_sc_hd__decap_40_12
XFILLER_45_493 vssd1 vccd1 vccd1 vssd1 X2_sky130_fd_sc_hd__fill_8
XFILLER_20_305 vssd1 vccd1 vccd1 vssd1 X2_sky130_fd_sc_hd__fill_2
XFILLER_32_165 vssd1 vccd1 vssd1 vccd1 X2_sky130_ef_sc_hd__decap_40_12
XTAP_TAPCELL_ROW_15_385 vccd1 vssd1 X2_sky130_fd_sc_hd__tapvpwrvgnd_1
XANTENNA__274__S _289_/S vssd1 vccd1 vccd1 vssd1 X2_sky130_fd_sc_hd__diode_2
XTAP_TAPCELL_ROW_43_694 vccd1 vssd1 X2_sky130_fd_sc_hd__tapvpwrvgnd_1
XFILLER_9_361 vssd1 vccd1 vssd1 vccd1 X2_sky130_ef_sc_hd__decap_40_12
XFILLER_87_305 vssd1 vccd1 vssd1 vccd1 X2_sky130_ef_sc_hd__decap_40_12
XFILLER_99_165 vssd1 vccd1 vccd1 vssd1 X2_sky130_fd_sc_hd__fill_2
XFILLER_101_137 vssd1 vccd1 vccd1 vssd1 X2_sky130_fd_sc_hd__fill_2
XFILLER_95_393 vssd1 vccd1 vssd1 vccd1 X2_sky130_ef_sc_hd__decap_40_12
XFILLER_46_29 vssd1 vccd1 vssd1 vccd1 X2_sky130_ef_sc_hd__decap_40_12
XFILLER_55_279 vccd1 vssd1 vccd1 vssd1 X2_sky130_fd_sc_hd__fill_1
XFILLER_70_249 vssd1 vccd1 vccd1 vssd1 X2_sky130_fd_sc_hd__fill_2
XFILLER_11_305 vssd1 vccd1 vssd1 vccd1 X2_sky130_ef_sc_hd__decap_40_12
XFILLER_23_165 vssd1 vccd1 vccd1 vssd1 X2_sky130_fd_sc_hd__fill_2
XANTENNA__339__B1 _317_/C vssd1 vccd1 vccd1 vssd1 X2_sky130_fd_sc_hd__diode_2
XFILLER_11_349 vssd1 vccd1 vssd1 vccd1 X2_sky130_ef_sc_hd__decap_40_12
XTAP_TAPCELL_ROW_98_1298 vccd1 vssd1 X2_sky130_fd_sc_hd__tapvpwrvgnd_1
XFILLER_3_559 vccd1 vssd1 vccd1 vssd1 X2_sky130_fd_sc_hd__fill_1
XFILLER_78_305 vssd1 vccd1 vccd1 vssd1 X2_sky130_fd_sc_hd__fill_2
XFILLER_87_69 vssd1 vccd1 vssd1 vccd1 X2_sky130_ef_sc_hd__decap_40_12
XFILLER_59_541 vssd1 vccd1 vssd1 vccd1 X2_sky130_ef_sc_hd__decap_40_12
XFILLER_19_405 vssd1 vccd1 vssd1 vccd1 X2_sky130_ef_sc_hd__decap_40_12
XFILLER_93_308 vssd1 vccd1 vssd1 vccd1 X2_sky130_ef_sc_hd__decap_40_12
XFILLER_74_533 vssd1 vccd1 vssd1 vccd1 X2_sky130_ef_sc_hd__decap_40_12
XFILLER_59_585 vssd1 vccd1 vssd1 vccd1 X2_sky130_ef_sc_hd__decap_40_12
XFILLER_19_449 vssd1 vccd1 vssd1 vccd1 X2_sky130_ef_sc_hd__decap_40_12
XFILLER_74_599 vssd1 vccd1 vccd1 vssd1 X2_sky130_fd_sc_hd__fill_2
XFILLER_61_205 vssd1 vccd1 vssd1 vccd1 X2_sky130_ef_sc_hd__decap_40_12
XFILLER_46_279 vssd1 vccd1 vccd1 vssd1 X2_sky130_fd_sc_hd__fill_2
XFILLER_14_121 vssd1 vccd1 vssd1 vccd1 X2_sky130_ef_sc_hd__decap_40_12
XFILLER_14_165 vssd1 vccd1 vssd1 vccd1 X2_sky130_ef_sc_hd__decap_40_12
X_315_ vssd1 vccd1 _315_/X _317_/B _539_/Q _317_/C vccd1 vssd1 X2_sky130_fd_sc_hd__and3_1
XFILLER_52_83 vccd1 vssd1 vccd1 vssd1 X2_sky130_fd_sc_hd__fill_1
XTAP_TAPCELL_ROW_12_355 vccd1 vssd1 X2_sky130_fd_sc_hd__tapvpwrvgnd_1
XTAP_TAPCELL_ROW_40_664 vccd1 vssd1 X2_sky130_fd_sc_hd__tapvpwrvgnd_1
Xinput37 vssd1 vccd1 _281_/A0 wbs_dat_i[8] vccd1 vssd1 X2_sky130_fd_sc_hd__clkbuf_1
Xinput26 vssd1 vccd1 _277_/A0 wbs_dat_i[12] vccd1 vssd1 X2_sky130_fd_sc_hd__clkbuf_1
Xinput15 vssd1 vccd1 _269_/A wbs_adr_i[1] vccd1 vssd1 X2_sky130_fd_sc_hd__clkbuf_1
XTAP_TAPCELL_ROW_75_1040 vccd1 vssd1 X2_sky130_fd_sc_hd__tapvpwrvgnd_1
XFILLER_69_305 vssd1 vccd1 vssd1 vccd1 X2_sky130_ef_sc_hd__decap_40_12
XFILLER_2_581 vssd1 vccd1 vccd1 vssd1 X2_sky130_fd_sc_hd__fill_4
XFILLER_69_349 vssd1 vccd1 vssd1 vccd1 X2_sky130_ef_sc_hd__decap_40_12
XFILLER_77_393 vssd1 vccd1 vssd1 vccd1 X2_sky130_ef_sc_hd__decap_40_12
XTAP_TAPCELL_ROW_48_753 vccd1 vssd1 X2_sky130_fd_sc_hd__tapvpwrvgnd_1
XFILLER_37_279 vccd1 vssd1 vccd1 vssd1 X2_sky130_fd_sc_hd__fill_1
XFILLER_80_525 vssd1 vccd1 vccd1 vssd1 X2_sky130_fd_sc_hd__fill_4
XFILLER_80_569 vssd1 vccd1 vssd1 vccd1 X2_sky130_ef_sc_hd__decap_40_12
XFILLER_33_485 vssd1 vccd1 vssd1 vccd1 X2_sky130_ef_sc_hd__decap_40_12
XFILLER_60_260 vssd1 vccd1 vccd1 vssd1 X2_sky130_fd_sc_hd__fill_8
XANTENNA_clkbuf_3_6__f_wb_clk_i_A clkbuf_0_wb_clk_i/X vssd1 vccd1 vccd1 vssd1 X2_sky130_fd_sc_hd__diode_2
XFILLER_87_113 vssd1 vccd1 vssd1 vccd1 X2_sky130_ef_sc_hd__decap_40_12
XFILLER_57_39 vssd1 vccd1 vssd1 vccd1 X2_sky130_ef_sc_hd__decap_40_12
XFILLER_56_533 vssd1 vccd1 vssd1 vccd1 X2_sky130_ef_sc_hd__decap_40_12
XFILLER_16_419 vccd1 vssd1 vccd1 vssd1 X2_sky130_fd_sc_hd__fill_1
XFILLER_83_385 vssd1 vccd1 vccd1 vssd1 X2_sky130_fd_sc_hd__fill_4
XFILLER_73_27 vssd1 vccd1 vssd1 vccd1 X2_sky130_ef_sc_hd__decap_40_12
XFILLER_71_503 vccd1 vssd1 vccd1 vssd1 X2_sky130_fd_sc_hd__fill_1
XFILLER_43_249 vssd1 vccd1 vssd1 vccd1 X2_sky130_ef_sc_hd__decap_40_12
XFILLER_11_113 vssd1 vccd1 vssd1 vccd1 X2_sky130_ef_sc_hd__decap_40_12
XFILLER_51_293 vssd1 vccd1 vssd1 vccd1 X2_sky130_ef_sc_hd__decap_40_12
XFILLER_22_53 vssd1 vccd1 vssd1 vccd1 X2_sky130_ef_sc_hd__decap_40_12
XFILLER_22_97 vssd1 vccd1 vssd1 vccd1 X2_sky130_ef_sc_hd__decap_40_12
XFILLER_3_389 vssd1 vccd1 vccd1 vssd1 X2_sky130_fd_sc_hd__fill_2
XFILLER_93_105 vssd1 vccd1 vccd1 vssd1 X2_sky130_fd_sc_hd__fill_4
XFILLER_93_149 vssd1 vccd1 vssd1 vccd1 X2_sky130_ef_sc_hd__decap_40_12
XFILLER_59_393 vssd1 vccd1 vssd1 vccd1 X2_sky130_ef_sc_hd__decap_40_12
XTAP_TAPCELL_ROW_17_403 vccd1 vssd1 X2_sky130_fd_sc_hd__tapvpwrvgnd_1
XFILLER_19_279 vccd1 vssd1 vccd1 vssd1 X2_sky130_fd_sc_hd__fill_1
XFILLER_34_205 vccd1 vssd1 vccd1 vssd1 X2_sky130_fd_sc_hd__fill_1
XFILLER_74_363 vccd1 vssd1 vccd1 vssd1 X2_sky130_fd_sc_hd__fill_1
XFILLER_62_525 vssd1 vccd1 vccd1 vssd1 X2_sky130_fd_sc_hd__fill_4
XTAP_TAPCELL_ROW_45_712 vccd1 vssd1 X2_sky130_fd_sc_hd__tapvpwrvgnd_1
XFILLER_15_441 vssd1 vccd1 vccd1 vssd1 X2_sky130_fd_sc_hd__fill_4
XFILLER_15_485 vssd1 vccd1 vssd1 vccd1 X2_sky130_ef_sc_hd__decap_40_12
XFILLER_63_93 vssd1 vccd1 vssd1 vccd1 X2_sky130_ef_sc_hd__decap_40_12
XTAP_TAPCELL_ROW_25_491 vccd1 vssd1 X2_sky130_fd_sc_hd__tapvpwrvgnd_1
XFILLER_30_433 vssd1 vccd1 vssd1 vccd1 X2_sky130_ef_sc_hd__decap_40_12
XFILLER_30_477 vssd1 vccd1 vssd1 vccd1 X2_sky130_ef_sc_hd__decap_40_12
XFILLER_8_77 vssd1 vccd1 vccd1 vssd1 X2_sky130_fd_sc_hd__fill_4
XFILLER_40_3 vssd1 vccd1 vssd1 vccd1 X2_sky130_ef_sc_hd__decap_40_12
XFILLER_97_411 vccd1 vssd1 vccd1 vssd1 X2_sky130_fd_sc_hd__fill_1
XFILLER_69_113 vssd1 vccd1 vssd1 vccd1 X2_sky130_ef_sc_hd__decap_40_12
Xtop_soc_70 wbs_dat_o[18] top_soc_70/HI vccd1 vssd1 vssd1 vccd1 X2_sky130_fd_sc_hd__conb_1
XFILLER_85_617 vssd1 vccd1 vccd1 vssd1 X2_sky130_fd_sc_hd__fill_8
Xtop_soc_81 wbs_dat_o[29] top_soc_81/HI vccd1 vssd1 vssd1 vccd1 X2_sky130_fd_sc_hd__conb_1
XFILLER_38_533 vccd1 vssd1 vccd1 vssd1 X2_sky130_fd_sc_hd__fill_1
XFILLER_25_205 vssd1 vccd1 vssd1 vccd1 X2_sky130_ef_sc_hd__decap_40_12
XFILLER_53_503 vccd1 vssd1 vccd1 vssd1 X2_sky130_fd_sc_hd__fill_1
XFILLER_25_249 vssd1 vccd1 vssd1 vccd1 X2_sky130_ef_sc_hd__decap_40_12
XFILLER_92_193 vssd1 vccd1 vccd1 vssd1 X2_sky130_fd_sc_hd__fill_2
XTAP_TAPCELL_ROW_84_1139 vccd1 vssd1 X2_sky130_fd_sc_hd__tapvpwrvgnd_1
XFILLER_80_333 vssd1 vccd1 vssd1 vccd1 X2_sky130_ef_sc_hd__decap_40_12
XFILLER_80_377 vssd1 vccd1 vssd1 vccd1 X2_sky130_ef_sc_hd__decap_40_12
XFILLER_4_109 vssd1 vccd1 vssd1 vccd1 X2_sky130_ef_sc_hd__decap_40_12
XTAP_TAPCELL_ROW_95_1268 vccd1 vssd1 X2_sky130_fd_sc_hd__tapvpwrvgnd_1
XFILLER_0_337 vccd1 vssd1 vccd1 vssd1 X2_sky130_fd_sc_hd__fill_1
XFILLER_88_433 vssd1 vccd1 vssd1 vccd1 X2_sky130_ef_sc_hd__decap_40_12
XFILLER_68_27 vccd1 vssd1 vccd1 vssd1 X2_sky130_fd_sc_hd__fill_1
XFILLER_88_477 vssd1 vccd1 vssd1 vccd1 X2_sky130_ef_sc_hd__decap_40_12
XFILLER_75_105 vssd1 vccd1 vccd1 vssd1 X2_sky130_fd_sc_hd__fill_4
XFILLER_91_609 vssd1 vccd1 vccd1 vssd1 X2_sky130_fd_sc_hd__fill_4
XFILLER_84_15 vssd1 vccd1 vssd1 vccd1 X2_sky130_ef_sc_hd__decap_40_12
XFILLER_75_149 vssd1 vccd1 vssd1 vccd1 X2_sky130_ef_sc_hd__decap_40_12
X_580_ vccd1 vssd1 vccd1 vssd1 _580_/Q _500_/Y _580_/D _609_/CLK X2_sky130_fd_sc_hd__dfstp_1
XFILLER_83_193 vssd1 vccd1 vssd1 vccd1 X2_sky130_ef_sc_hd__decap_40_12
XFILLER_71_333 vssd1 vccd1 vccd1 vssd1 X2_sky130_fd_sc_hd__fill_2
XFILLER_16_249 vssd1 vccd1 vccd1 vssd1 X2_sky130_fd_sc_hd__fill_2
XFILLER_12_433 vssd1 vccd1 vssd1 vccd1 X2_sky130_ef_sc_hd__decap_40_12
XFILLER_12_477 vssd1 vccd1 vssd1 vccd1 X2_sky130_ef_sc_hd__decap_40_12
XTAP_TAPCELL_ROW_22_461 vccd1 vssd1 X2_sky130_fd_sc_hd__tapvpwrvgnd_1
XTAP_TAPCELL_ROW_50_770 vccd1 vssd1 X2_sky130_fd_sc_hd__tapvpwrvgnd_1
XPHY_EDGE_ROW_49_Left_151 vccd1 vssd1 vccd1 vssd1 X2_sky130_fd_sc_hd__decap_3
XTAP_TAPCELL_ROW_72_1010 vccd1 vssd1 X2_sky130_fd_sc_hd__tapvpwrvgnd_1
XFILLER_67_617 vssd1 vccd1 vccd1 vssd1 X2_sky130_fd_sc_hd__fill_2
Xhold4 hold4/X hold4/A vccd1 vssd1 vssd1 vccd1 X2_sky130_fd_sc_hd__dlygate4sd3_1
XFILLER_39_319 vssd1 vccd1 vssd1 vccd1 X2_sky130_ef_sc_hd__decap_40_12
XPHY_EDGE_ROW_58_Left_160 vccd1 vssd1 vccd1 vssd1 X2_sky130_fd_sc_hd__decap_3
XFILLER_94_469 vssd1 vccd1 vccd1 vssd1 X2_sky130_fd_sc_hd__fill_4
XFILLER_74_193 vssd1 vccd1 vccd1 vssd1 X2_sky130_fd_sc_hd__fill_2
XFILLER_62_333 vssd1 vccd1 vccd1 vssd1 X2_sky130_fd_sc_hd__fill_8
XFILLER_35_558 vssd1 vccd1 vccd1 vssd1 X2_sky130_fd_sc_hd__fill_2
XFILLER_74_81 vssd1 vccd1 vccd1 vssd1 X2_sky130_fd_sc_hd__fill_2
XFILLER_50_506 vssd1 vccd1 vssd1 vccd1 X2_sky130_ef_sc_hd__decap_40_12
XFILLER_62_377 vssd1 vccd1 vssd1 vccd1 X2_sky130_ef_sc_hd__decap_40_12
XFILLER_15_293 vssd1 vccd1 vssd1 vccd1 X2_sky130_ef_sc_hd__decap_40_12
XFILLER_88_3 vssd1 vccd1 vssd1 vccd1 X2_sky130_ef_sc_hd__decap_40_12
XANTENNA__282__S _289_/S vssd1 vccd1 vccd1 vssd1 X2_sky130_fd_sc_hd__diode_2
XFILLER_57_105 vssd1 vccd1 vccd1 vssd1 X2_sky130_fd_sc_hd__fill_4
XFILLER_85_447 vccd1 vssd1 vccd1 vssd1 X2_sky130_fd_sc_hd__fill_1
XFILLER_57_149 vssd1 vccd1 vssd1 vccd1 X2_sky130_ef_sc_hd__decap_40_12
XFILLER_38_352 vssd1 vccd1 vssd1 vccd1 X2_sky130_ef_sc_hd__decap_40_12
XFILLER_26_525 vssd1 vccd1 vccd1 vssd1 X2_sky130_fd_sc_hd__fill_4
XFILLER_54_29 vssd1 vccd1 vssd1 vccd1 X2_sky130_ef_sc_hd__decap_40_12
XFILLER_53_333 vssd1 vccd1 vccd1 vssd1 X2_sky130_fd_sc_hd__fill_2
XFILLER_26_569 vssd1 vccd1 vssd1 vccd1 X2_sky130_ef_sc_hd__decap_40_12
XFILLER_80_141 vssd1 vccd1 vssd1 vccd1 X2_sky130_ef_sc_hd__decap_40_12
XFILLER_65_193 vssd1 vccd1 vssd1 vccd1 X2_sky130_ef_sc_hd__decap_40_12
XFILLER_34_580 vssd1 vccd1 vccd1 vssd1 X2_sky130_fd_sc_hd__fill_8
XFILLER_41_517 vssd1 vccd1 vccd1 vssd1 X2_sky130_fd_sc_hd__fill_8
XPHY_EDGE_ROW_17_Right_17 vccd1 vssd1 vccd1 vssd1 X2_sky130_fd_sc_hd__decap_3
XFILLER_5_429 vssd1 vccd1 vssd1 vccd1 X2_sky130_ef_sc_hd__decap_40_12
XFILLER_79_15 vssd1 vccd1 vssd1 vccd1 X2_sky130_ef_sc_hd__decap_40_12
XFILLER_1_613 vssd1 vccd1 vccd1 vssd1 X2_sky130_fd_sc_hd__fill_2
XFILLER_0_167 vccd1 vssd1 vccd1 vssd1 X2_sky130_fd_sc_hd__fill_1
XPHY_EDGE_ROW_26_Right_26 vccd1 vssd1 vccd1 vssd1 X2_sky130_fd_sc_hd__decap_3
XANTENNA__550__CLK _553_/CLK vssd1 vccd1 vccd1 vssd1 X2_sky130_fd_sc_hd__diode_2
XFILLER_49_617 vssd1 vccd1 vccd1 vssd1 X2_sky130_fd_sc_hd__fill_4
XFILLER_0_189 vssd1 vccd1 vccd1 vssd1 X2_sky130_fd_sc_hd__fill_2
XFILLER_28_41 vssd1 vccd1 vssd1 vccd1 X2_sky130_ef_sc_hd__decap_40_12
XFILLER_95_69 vssd1 vccd1 vssd1 vccd1 X2_sky130_ef_sc_hd__decap_40_12
XFILLER_17_503 vccd1 vssd1 vccd1 vssd1 X2_sky130_fd_sc_hd__fill_1
XFILLER_91_417 vssd1 vccd1 vssd1 vccd1 X2_sky130_ef_sc_hd__decap_40_12
XFILLER_76_469 vssd1 vccd1 vccd1 vssd1 X2_sky130_fd_sc_hd__fill_4
XFILLER_28_85 vssd1 vccd1 vssd1 vccd1 X2_sky130_ef_sc_hd__decap_40_12
XFILLER_29_385 vssd1 vccd1 vccd1 vssd1 X2_sky130_fd_sc_hd__fill_4
XTAP_TAPCELL_ROW_27_520 vccd1 vssd1 X2_sky130_fd_sc_hd__tapvpwrvgnd_1
XFILLER_32_506 vssd1 vccd1 vccd1 vssd1 X2_sky130_fd_sc_hd__fill_2
X_563_ vssd1 vccd1 vccd1 vssd1 _608_/CLK _563_/D _483_/Y _563_/Q X2_sky130_fd_sc_hd__dfrtp_1
XFILLER_56_193 vssd1 vccd1 vccd1 vssd1 X2_sky130_fd_sc_hd__fill_2
XFILLER_44_333 vssd1 vccd1 vssd1 vccd1 X2_sky130_ef_sc_hd__decap_40_12
XFILLER_32_517 vssd1 vccd1 vccd1 vssd1 X2_sky130_fd_sc_hd__fill_2
X_494_ vccd1 vssd1 vccd1 vssd1 _494_/Y _517_/A X2_sky130_fd_sc_hd__inv_2
XFILLER_44_377 vssd1 vccd1 vssd1 vccd1 X2_sky130_ef_sc_hd__decap_40_12
XPHY_EDGE_ROW_35_Right_35 vccd1 vssd1 vccd1 vssd1 X2_sky130_fd_sc_hd__decap_3
XFILLER_40_550 vssd1 vccd1 vssd1 vccd1 X2_sky130_ef_sc_hd__decap_40_12
XFILLER_8_245 vssd1 vccd1 vccd1 vssd1 X2_sky130_fd_sc_hd__fill_4
XFILLER_60_83 vccd1 vssd1 vccd1 vssd1 X2_sky130_fd_sc_hd__fill_1
XFILLER_8_289 vssd1 vccd1 vssd1 vccd1 X2_sky130_ef_sc_hd__decap_40_12
XFILLER_99_517 vssd1 vccd1 vssd1 vccd1 X2_sky130_ef_sc_hd__decap_40_12
XFILLER_4_473 vssd1 vccd1 vccd1 vssd1 X2_sky130_fd_sc_hd__fill_2
XFILLER_69_81 vssd1 vccd1 vssd1 vccd1 X2_sky130_ef_sc_hd__decap_40_12
XPHY_EDGE_ROW_44_Right_44 vccd1 vssd1 vccd1 vssd1 X2_sky130_fd_sc_hd__decap_3
XFILLER_39_105 vssd1 vccd1 vccd1 vssd1 X2_sky130_fd_sc_hd__fill_4
XFILLER_39_149 vssd1 vccd1 vssd1 vccd1 X2_sky130_ef_sc_hd__decap_40_12
XFILLER_94_233 vssd1 vccd1 vssd1 vccd1 X2_sky130_ef_sc_hd__decap_40_12
XFILLER_67_447 vccd1 vssd1 vccd1 vssd1 X2_sky130_fd_sc_hd__fill_1
XFILLER_94_277 vssd1 vccd1 vssd1 vccd1 X2_sky130_ef_sc_hd__decap_40_12
XFILLER_82_417 vssd1 vccd1 vccd1 vssd1 X2_sky130_fd_sc_hd__fill_2
XANTENNA__277__S _289_/S vssd1 vccd1 vccd1 vssd1 X2_sky130_fd_sc_hd__diode_2
XFILLER_63_620 vssd1 vccd1 vccd1 vssd1 X2_sky130_fd_sc_hd__fill_2
XFILLER_62_141 vssd1 vccd1 vssd1 vccd1 X2_sky130_ef_sc_hd__decap_40_12
XFILLER_47_193 vssd1 vccd1 vccd1 vssd1 X2_sky130_fd_sc_hd__fill_2
XFILLER_23_517 vssd1 vccd1 vssd1 vccd1 X2_sky130_ef_sc_hd__decap_40_12
XTAP_TAPCELL_ROW_81_1109 vccd1 vssd1 X2_sky130_fd_sc_hd__tapvpwrvgnd_1
XPHY_EDGE_ROW_53_Right_53 vccd1 vssd1 vccd1 vssd1 X2_sky130_fd_sc_hd__decap_3
XFILLER_31_561 vssd1 vccd1 vccd1 vssd1 X2_sky130_fd_sc_hd__fill_8
XTAP_TAPCELL_ROW_33_578 vccd1 vssd1 X2_sky130_fd_sc_hd__tapvpwrvgnd_1
XTAP_TAPCELL_ROW_61_887 vccd1 vssd1 X2_sky130_fd_sc_hd__tapvpwrvgnd_1
XTAP_TAPCELL_ROW_92_1227 vccd1 vssd1 X2_sky130_fd_sc_hd__tapvpwrvgnd_1
XPHY_EDGE_ROW_62_Right_62 vccd1 vssd1 vccd1 vssd1 X2_sky130_fd_sc_hd__decap_3
XANTENNA__573__CLK _606_/CLK vssd1 vccd1 vccd1 vssd1 X2_sky130_fd_sc_hd__diode_2
XFILLER_100_533 vssd1 vccd1 vssd1 vccd1 X2_sky130_ef_sc_hd__decap_40_12
XFILLER_85_277 vssd1 vccd1 vccd1 vssd1 X2_sky130_fd_sc_hd__fill_2
XFILLER_73_417 vssd1 vccd1 vssd1 vccd1 X2_sky130_ef_sc_hd__decap_40_12
XTAP_TAPCELL_ROW_69_976 vccd1 vssd1 X2_sky130_fd_sc_hd__tapvpwrvgnd_1
XFILLER_65_39 vssd1 vccd1 vssd1 vccd1 X2_sky130_ef_sc_hd__decap_40_12
XFILLER_58_469 vssd1 vccd1 vccd1 vssd1 X2_sky130_fd_sc_hd__fill_4
XFILLER_26_333 vssd1 vccd1 vssd1 vccd1 X2_sky130_ef_sc_hd__decap_40_12
XFILLER_26_377 vssd1 vccd1 vssd1 vccd1 X2_sky130_ef_sc_hd__decap_40_12
XFILLER_81_461 vssd1 vccd1 vssd1 vccd1 X2_sky130_ef_sc_hd__decap_40_12
XFILLER_81_27 vssd1 vccd1 vssd1 vccd1 X2_sky130_ef_sc_hd__decap_40_12
XPHY_EDGE_ROW_71_Right_71 vccd1 vssd1 vccd1 vssd1 X2_sky130_fd_sc_hd__decap_3
XFILLER_41_314 vccd1 vssd1 vccd1 vssd1 X2_sky130_fd_sc_hd__fill_1
XFILLER_53_185 vccd1 vssd1 vccd1 vssd1 X2_sky130_fd_sc_hd__fill_1
XFILLER_41_358 vssd1 vccd1 vccd1 vssd1 X2_sky130_fd_sc_hd__fill_2
XTAP_TAPCELL_ROW_101_1345 vccd1 vssd1 X2_sky130_fd_sc_hd__tapvpwrvgnd_1
XTAP_TAPCELL_ROW_101_1334 vccd1 vssd1 X2_sky130_fd_sc_hd__tapvpwrvgnd_1
XFILLER_14_65 vssd1 vccd1 vssd1 vccd1 X2_sky130_ef_sc_hd__decap_40_12
XFILLER_5_237 vssd1 vccd1 vssd1 vccd1 X2_sky130_ef_sc_hd__decap_40_12
XFILLER_30_53 vssd1 vccd1 vssd1 vccd1 X2_sky130_ef_sc_hd__decap_40_12
XPHY_EDGE_ROW_80_Right_80 vccd1 vssd1 vccd1 vssd1 X2_sky130_fd_sc_hd__decap_3
XFILLER_30_97 vssd1 vccd1 vssd1 vccd1 X2_sky130_ef_sc_hd__decap_40_12
XFILLER_89_561 vssd1 vccd1 vssd1 vccd1 X2_sky130_ef_sc_hd__decap_40_12
XFILLER_76_233 vssd1 vccd1 vssd1 vccd1 X2_sky130_ef_sc_hd__decap_40_12
XFILLER_49_436 vssd1 vccd1 vccd1 vssd1 X2_sky130_fd_sc_hd__fill_2
XFILLER_76_266 vssd1 vccd1 vccd1 vssd1 X2_sky130_fd_sc_hd__fill_2
XFILLER_91_225 vssd1 vccd1 vssd1 vccd1 X2_sky130_ef_sc_hd__decap_40_12
XFILLER_17_333 vssd1 vccd1 vccd1 vssd1 X2_sky130_fd_sc_hd__fill_2
XFILLER_29_193 vssd1 vccd1 vssd1 vccd1 X2_sky130_ef_sc_hd__decap_40_12
XFILLER_44_141 vssd1 vccd1 vssd1 vccd1 X2_sky130_ef_sc_hd__decap_40_12
X_546_ vssd1 vccd1 vccd1 vssd1 _608_/CLK hold6/X _466_/Y _546_/Q X2_sky130_fd_sc_hd__dfrtp_1
XFILLER_13_561 vssd1 vccd1 vssd1 vccd1 X2_sky130_ef_sc_hd__decap_40_12
X_477_ vccd1 vssd1 vccd1 vssd1 _477_/Y _517_/A X2_sky130_fd_sc_hd__inv_2
XTAP_TAPCELL_ROW_30_548 vccd1 vssd1 X2_sky130_fd_sc_hd__tapvpwrvgnd_1
XFILLER_71_93 vssd1 vccd1 vssd1 vccd1 X2_sky130_ef_sc_hd__decap_40_12
XFILLER_99_325 vccd1 vssd1 vccd1 vssd1 X2_sky130_fd_sc_hd__fill_1
XTAP_TAPCELL_ROW_78_1082 vccd1 vssd1 X2_sky130_fd_sc_hd__tapvpwrvgnd_1
XFILLER_95_553 vssd1 vccd1 vccd1 vssd1 X2_sky130_fd_sc_hd__fill_4
XFILLER_36_620 vssd1 vccd1 vccd1 vssd1 X2_sky130_fd_sc_hd__fill_2
XTAP_TAPCELL_ROW_38_637 vccd1 vssd1 X2_sky130_fd_sc_hd__tapvpwrvgnd_1
XFILLER_95_597 vssd1 vccd1 vssd1 vccd1 X2_sky130_ef_sc_hd__decap_40_12
XTAP_TAPCELL_ROW_66_946 vccd1 vssd1 X2_sky130_fd_sc_hd__tapvpwrvgnd_1
XFILLER_55_417 vssd1 vccd1 vssd1 vccd1 X2_sky130_ef_sc_hd__decap_40_12
XFILLER_48_480 vssd1 vccd1 vccd1 vssd1 X2_sky130_fd_sc_hd__fill_2
XFILLER_63_461 vssd1 vccd1 vssd1 vccd1 X2_sky130_ef_sc_hd__decap_40_12
XFILLER_51_623 vssd1 vccd1 vccd1 vssd1 X2_sky130_fd_sc_hd__fill_2
XFILLER_50_133 vssd1 vccd1 vccd1 vssd1 X2_sky130_fd_sc_hd__fill_4
XFILLER_50_177 vssd1 vccd1 vssd1 vccd1 X2_sky130_ef_sc_hd__decap_40_12
XFILLER_86_531 vccd1 vssd1 vccd1 vssd1 X2_sky130_fd_sc_hd__fill_1
XFILLER_76_27 vccd1 vssd1 vccd1 vssd1 X2_sky130_fd_sc_hd__fill_1
XFILLER_58_233 vssd1 vccd1 vssd1 vccd1 X2_sky130_ef_sc_hd__decap_40_12
XFILLER_19_609 vssd1 vccd1 vccd1 vssd1 X2_sky130_fd_sc_hd__fill_4
XFILLER_100_341 vssd1 vccd1 vccd1 vssd1 X2_sky130_fd_sc_hd__fill_2
XFILLER_100_385 vssd1 vccd1 vssd1 vccd1 X2_sky130_ef_sc_hd__decap_40_12
XFILLER_100_363 vccd1 vssd1 vccd1 vssd1 X2_sky130_fd_sc_hd__fill_1
XFILLER_73_225 vssd1 vccd1 vssd1 vccd1 X2_sky130_ef_sc_hd__decap_40_12
XFILLER_58_277 vssd1 vccd1 vccd1 vssd1 X2_sky130_fd_sc_hd__fill_2
XFILLER_92_15 vssd1 vccd1 vssd1 vccd1 X2_sky130_ef_sc_hd__decap_40_12
XFILLER_26_141 vssd1 vccd1 vssd1 vccd1 X2_sky130_ef_sc_hd__decap_40_12
X_400_ vssd1 vccd1 vccd1 vssd1 _400_/A _400_/X _400_/B X2_sky130_fd_sc_hd__xor2_1
XFILLER_42_601 vssd1 vccd1 vccd1 vssd1 X2_sky130_fd_sc_hd__fill_4
X_331_ vccd1 vssd1 vssd1 vccd1 _330_/X _317_/B hold21/X _329_/X _331_/X X2_sky130_fd_sc_hd__o22a_1
XFILLER_41_111 vccd1 vssd1 vccd1 vssd1 X2_sky130_fd_sc_hd__fill_1
X_262_ vccd1 vssd1 vccd1 vssd1 _262_/Y _545_/Q X2_sky130_fd_sc_hd__inv_2
XFILLER_10_531 vccd1 vssd1 vccd1 vssd1 X2_sky130_fd_sc_hd__fill_1
XFILLER_6_513 vssd1 vccd1 vssd1 vccd1 X2_sky130_ef_sc_hd__decap_40_12
XFILLER_6_557 vssd1 vccd1 vssd1 vccd1 X2_sky130_ef_sc_hd__decap_40_12
XFILLER_1_273 vccd1 vssd1 vccd1 vssd1 X2_sky130_fd_sc_hd__fill_1
XANTENNA_input30_X _298_/A0 vssd1 vccd1 vccd1 vssd1 X2_sky130_fd_sc_hd__diode_2
XFILLER_89_391 vccd1 vssd1 vccd1 vssd1 X2_sky130_fd_sc_hd__fill_1
XFILLER_49_222 vssd1 vccd1 vccd1 vssd1 X2_sky130_fd_sc_hd__fill_2
XANTENNA__293__A0 _449_/A1 vssd1 vccd1 vccd1 vssd1 X2_sky130_fd_sc_hd__diode_2
XFILLER_92_501 vssd1 vccd1 vssd1 vccd1 X2_sky130_ef_sc_hd__decap_40_12
XFILLER_77_553 vssd1 vccd1 vccd1 vssd1 X2_sky130_fd_sc_hd__fill_4
XFILLER_37_417 vssd1 vccd1 vccd1 vssd1 X2_sky130_fd_sc_hd__fill_2
XFILLER_77_597 vssd1 vccd1 vssd1 vccd1 X2_sky130_ef_sc_hd__decap_40_12
XFILLER_49_277 vssd1 vccd1 vccd1 vssd1 X2_sky130_fd_sc_hd__fill_2
XFILLER_92_545 vssd1 vccd1 vssd1 vccd1 X2_sky130_ef_sc_hd__decap_40_12
XFILLER_33_612 vssd1 vccd1 vccd1 vssd1 X2_sky130_fd_sc_hd__fill_4
XTAP_TAPCELL_ROW_35_607 vccd1 vssd1 X2_sky130_fd_sc_hd__tapvpwrvgnd_1
XFILLER_92_589 vssd1 vccd1 vssd1 vccd1 X2_sky130_ef_sc_hd__decap_40_12
XTAP_TAPCELL_ROW_63_916 vccd1 vssd1 X2_sky130_fd_sc_hd__tapvpwrvgnd_1
XFILLER_45_461 vssd1 vccd1 vssd1 vccd1 X2_sky130_ef_sc_hd__decap_40_12
XFILLER_45_483 vssd1 vccd1 vccd1 vssd1 X2_sky130_fd_sc_hd__fill_2
XFILLER_32_133 vssd1 vccd1 vccd1 vssd1 X2_sky130_fd_sc_hd__fill_4
XFILLER_82_81 vssd1 vccd1 vccd1 vssd1 X2_sky130_fd_sc_hd__fill_2
X_529_ vccd1 vssd1 vccd1 vssd1 _529_/Y _529_/A X2_sky130_fd_sc_hd__inv_2
XTAP_TAPCELL_ROW_15_386 vccd1 vssd1 X2_sky130_fd_sc_hd__tapvpwrvgnd_1
XFILLER_32_177 vssd1 vccd1 vssd1 vccd1 X2_sky130_ef_sc_hd__decap_40_12
XFILLER_60_475 vccd1 vssd1 vccd1 vssd1 X2_sky130_fd_sc_hd__fill_1
XTAP_TAPCELL_ROW_43_695 vccd1 vssd1 X2_sky130_fd_sc_hd__tapvpwrvgnd_1
XFILLER_13_391 vccd1 vssd1 vccd1 vssd1 X2_sky130_fd_sc_hd__fill_1
XFILLER_9_373 vssd1 vccd1 vssd1 vccd1 X2_sky130_ef_sc_hd__decap_40_12
XFILLER_70_3 vssd1 vccd1 vssd1 vccd1 X2_sky130_ef_sc_hd__decap_40_12
XFILLER_99_111 vccd1 vssd1 vccd1 vssd1 X2_sky130_fd_sc_hd__fill_1
XFILLER_87_317 vssd1 vccd1 vccd1 vssd1 X2_sky130_fd_sc_hd__fill_8
XFILLER_68_531 vccd1 vssd1 vccd1 vssd1 X2_sky130_fd_sc_hd__fill_1
XANTENNA__284__A0 _448_/A1 vssd1 vccd1 vccd1 vssd1 X2_sky130_fd_sc_hd__diode_2
XANTENNA_hold19_X _547_/D vssd1 vccd1 vccd1 vssd1 X2_sky130_fd_sc_hd__diode_2
XFILLER_95_350 vssd1 vccd1 vccd1 vssd1 X2_sky130_fd_sc_hd__fill_2
XFILLER_28_417 vssd1 vccd1 vccd1 vssd1 X2_sky130_fd_sc_hd__fill_2
XFILLER_83_501 vssd1 vccd1 vccd1 vssd1 X2_sky130_fd_sc_hd__fill_2
XFILLER_68_586 vssd1 vccd1 vccd1 vssd1 X2_sky130_fd_sc_hd__fill_2
XFILLER_55_225 vssd1 vccd1 vssd1 vccd1 X2_sky130_ef_sc_hd__decap_40_12
XFILLER_24_601 vssd1 vccd1 vssd1 vccd1 X2_sky130_ef_sc_hd__decap_40_12
XFILLER_23_111 vccd1 vssd1 vccd1 vssd1 X2_sky130_fd_sc_hd__fill_1
XFILLER_51_431 vssd1 vccd1 vssd1 vccd1 X2_sky130_ef_sc_hd__decap_40_12
XFILLER_62_29 vssd1 vccd1 vssd1 vccd1 X2_sky130_ef_sc_hd__decap_40_12
XFILLER_11_317 vssd1 vccd1 vssd1 vccd1 X2_sky130_ef_sc_hd__decap_40_12
XPHY_EDGE_ROW_12_Left_114 vccd1 vssd1 vccd1 vssd1 X2_sky130_fd_sc_hd__decap_3
XFILLER_3_505 vssd1 vccd1 vssd1 vccd1 X2_sky130_ef_sc_hd__decap_40_12
XFILLER_11_55 vccd1 vssd1 vccd1 vssd1 X2_sky130_fd_sc_hd__fill_1
XTAP_TAPCELL_ROW_98_1299 vccd1 vssd1 X2_sky130_fd_sc_hd__tapvpwrvgnd_1
XFILLER_87_15 vssd1 vccd1 vssd1 vccd1 X2_sky130_ef_sc_hd__decap_40_12
XPHY_EDGE_ROW_21_Left_123 vccd1 vssd1 vccd1 vssd1 X2_sky130_fd_sc_hd__decap_3
XFILLER_59_553 vssd1 vccd1 vccd1 vssd1 X2_sky130_fd_sc_hd__fill_4
XFILLER_19_417 vssd1 vccd1 vssd1 vccd1 X2_sky130_ef_sc_hd__decap_40_12
XFILLER_86_361 vssd1 vccd1 vccd1 vssd1 X2_sky130_fd_sc_hd__fill_2
XFILLER_74_501 vssd1 vccd1 vssd1 vccd1 X2_sky130_ef_sc_hd__decap_40_12
XFILLER_59_597 vssd1 vccd1 vccd1 vssd1 X2_sky130_fd_sc_hd__fill_2
XFILLER_100_193 vssd1 vccd1 vccd1 vssd1 X2_sky130_fd_sc_hd__fill_2
XFILLER_74_545 vssd1 vccd1 vssd1 vccd1 X2_sky130_ef_sc_hd__decap_40_12
XFILLER_46_236 vccd1 vssd1 vccd1 vssd1 X2_sky130_fd_sc_hd__fill_1
XFILLER_27_461 vssd1 vccd1 vssd1 vccd1 X2_sky130_ef_sc_hd__decap_40_12
XFILLER_36_41 vssd1 vccd1 vssd1 vccd1 X2_sky130_ef_sc_hd__decap_40_12
XFILLER_74_589 vccd1 vssd1 vccd1 vssd1 X2_sky130_fd_sc_hd__fill_1
XFILLER_61_217 vssd1 vccd1 vccd1 vssd1 X2_sky130_fd_sc_hd__fill_4
XFILLER_46_269 vssd1 vccd1 vccd1 vssd1 X2_sky130_fd_sc_hd__fill_2
XFILLER_36_85 vssd1 vccd1 vssd1 vccd1 X2_sky130_ef_sc_hd__decap_40_12
XFILLER_14_133 vssd1 vccd1 vccd1 vssd1 X2_sky130_fd_sc_hd__fill_4
XFILLER_14_177 vssd1 vccd1 vssd1 vccd1 X2_sky130_ef_sc_hd__decap_40_12
XPHY_EDGE_ROW_30_Left_132 vccd1 vssd1 vccd1 vssd1 X2_sky130_fd_sc_hd__decap_3
XFILLER_30_615 vccd1 vssd1 vccd1 vssd1 X2_sky130_fd_sc_hd__fill_1
X_314_ vccd1 vssd1 vccd1 vssd1 hold38/X _303_/X _314_/X _304_/X _600_/Q _313_/X X2_sky130_fd_sc_hd__a221o_1
XFILLER_42_475 vccd1 vssd1 vccd1 vssd1 X2_sky130_fd_sc_hd__fill_1
XFILLER_10_361 vssd1 vccd1 vccd1 vssd1 X2_sky130_fd_sc_hd__fill_2
XTAP_TAPCELL_ROW_12_356 vccd1 vssd1 X2_sky130_fd_sc_hd__tapvpwrvgnd_1
XTAP_TAPCELL_ROW_40_665 vccd1 vssd1 X2_sky130_fd_sc_hd__tapvpwrvgnd_1
Xinput27 vssd1 vccd1 _276_/A0 wbs_dat_i[13] vccd1 vssd1 X2_sky130_fd_sc_hd__clkbuf_1
Xinput16 vssd1 vccd1 wbs_adr_i[2] _320_/B vccd1 vssd1 X2_sky130_fd_sc_hd__clkbuf_2
XFILLER_6_321 vssd1 vccd1 vssd1 vccd1 X2_sky130_ef_sc_hd__decap_40_12
Xinput38 vssd1 vccd1 _280_/A0 wbs_dat_i[9] vccd1 vssd1 X2_sky130_fd_sc_hd__clkbuf_1
XFILLER_6_365 vssd1 vccd1 vssd1 vccd1 X2_sky130_ef_sc_hd__decap_40_12
XTAP_TAPCELL_ROW_75_1041 vccd1 vssd1 X2_sky130_fd_sc_hd__tapvpwrvgnd_1
XFILLER_97_615 vccd1 vssd1 vccd1 vssd1 X2_sky130_fd_sc_hd__fill_1
XFILLER_69_317 vssd1 vccd1 vccd1 vssd1 X2_sky130_fd_sc_hd__fill_2
XFILLER_42_7 vssd1 vccd1 vccd1 vssd1 X2_sky130_fd_sc_hd__fill_2
XFILLER_84_309 vssd1 vccd1 vssd1 vccd1 X2_sky130_ef_sc_hd__decap_40_12
XFILLER_77_81 vssd1 vccd1 vssd1 vccd1 X2_sky130_ef_sc_hd__decap_40_12
XFILLER_77_361 vssd1 vccd1 vssd1 vccd1 X2_sky130_ef_sc_hd__decap_40_12
XFILLER_37_225 vccd1 vssd1 vccd1 vssd1 X2_sky130_fd_sc_hd__fill_1
XTAP_TAPCELL_ROW_48_743 vccd1 vssd1 X2_sky130_fd_sc_hd__tapvpwrvgnd_1
XANTENNA__285__S _289_/S vssd1 vccd1 vccd1 vssd1 X2_sky130_fd_sc_hd__diode_2
XFILLER_33_420 vssd1 vccd1 vccd1 vssd1 X2_sky130_fd_sc_hd__fill_2
XTAP_TAPCELL_ROW_86_1170 vccd1 vssd1 X2_sky130_fd_sc_hd__tapvpwrvgnd_1
XFILLER_21_615 vccd1 vssd1 vccd1 vssd1 X2_sky130_fd_sc_hd__fill_1
XFILLER_33_497 vssd1 vccd1 vccd1 vssd1 X2_sky130_fd_sc_hd__fill_4
XFILLER_9_181 vssd1 vccd1 vssd1 vccd1 X2_sky130_ef_sc_hd__decap_40_12
XFILLER_87_125 vssd1 vccd1 vssd1 vccd1 X2_sky130_ef_sc_hd__decap_40_12
XFILLER_87_169 vssd1 vccd1 vssd1 vccd1 X2_sky130_ef_sc_hd__decap_40_12
XFILLER_56_501 vssd1 vccd1 vssd1 vccd1 X2_sky130_ef_sc_hd__decap_40_12
XFILLER_56_545 vssd1 vccd1 vssd1 vccd1 X2_sky130_ef_sc_hd__decap_40_12
XFILLER_56_589 vccd1 vssd1 vccd1 vssd1 X2_sky130_fd_sc_hd__fill_1
XFILLER_73_39 vssd1 vccd1 vssd1 vccd1 X2_sky130_ef_sc_hd__decap_40_12
XFILLER_71_559 vccd1 vssd1 vccd1 vssd1 X2_sky130_fd_sc_hd__fill_1
XFILLER_24_475 vccd1 vssd1 vccd1 vssd1 X2_sky130_fd_sc_hd__fill_1
XFILLER_11_125 vssd1 vccd1 vssd1 vccd1 X2_sky130_ef_sc_hd__decap_40_12
XFILLER_11_169 vssd1 vccd1 vssd1 vccd1 X2_sky130_ef_sc_hd__decap_40_12
XFILLER_22_65 vssd1 vccd1 vssd1 vccd1 X2_sky130_ef_sc_hd__decap_40_12
XFILLER_3_335 vccd1 vssd1 vccd1 vssd1 X2_sky130_fd_sc_hd__fill_1
XFILLER_0_3 vssd1 vccd1 vssd1 vccd1 X2_sky130_ef_sc_hd__decap_40_12
XFILLER_79_615 vccd1 vssd1 vccd1 vssd1 X2_sky130_fd_sc_hd__fill_1
XANTENNA_input38_A wbs_dat_i[9] vssd1 vccd1 vccd1 vssd1 X2_sky130_fd_sc_hd__diode_2
XFILLER_66_309 vssd1 vccd1 vssd1 vccd1 X2_sky130_ef_sc_hd__decap_40_12
XFILLER_59_361 vssd1 vccd1 vssd1 vccd1 X2_sky130_ef_sc_hd__decap_40_12
XFILLER_19_225 vssd1 vccd1 vssd1 vccd1 X2_sky130_ef_sc_hd__decap_40_12
XTAP_TAPCELL_ROW_17_404 vccd1 vssd1 X2_sky130_fd_sc_hd__tapvpwrvgnd_1
XTAP_TAPCELL_ROW_45_713 vccd1 vssd1 X2_sky130_fd_sc_hd__tapvpwrvgnd_1
XFILLER_30_401 vssd1 vccd1 vssd1 vccd1 X2_sky130_ef_sc_hd__decap_40_12
XFILLER_70_581 vssd1 vccd1 vccd1 vssd1 X2_sky130_fd_sc_hd__fill_4
XFILLER_15_497 vssd1 vccd1 vccd1 vssd1 X2_sky130_fd_sc_hd__fill_4
XTAP_TAPCELL_ROW_25_492 vccd1 vssd1 X2_sky130_fd_sc_hd__tapvpwrvgnd_1
XFILLER_30_445 vssd1 vccd1 vssd1 vccd1 X2_sky130_ef_sc_hd__decap_40_12
XFILLER_70_592 vssd1 vccd1 vssd1 vccd1 X2_sky130_ef_sc_hd__decap_40_12
XFILLER_30_489 vssd1 vccd1 vssd1 vccd1 X2_sky130_ef_sc_hd__decap_40_12
XFILLER_6_195 vccd1 vssd1 vccd1 vssd1 X2_sky130_fd_sc_hd__fill_1
XFILLER_33_3 vssd1 vccd1 vssd1 vccd1 X2_sky130_ef_sc_hd__decap_40_12
XFILLER_69_125 vssd1 vccd1 vssd1 vccd1 X2_sky130_ef_sc_hd__decap_40_12
Xtop_soc_71 wbs_dat_o[19] top_soc_71/HI vccd1 vssd1 vssd1 vccd1 X2_sky130_fd_sc_hd__conb_1
Xtop_soc_82 wbs_dat_o[30] top_soc_82/HI vccd1 vssd1 vssd1 vccd1 X2_sky130_fd_sc_hd__conb_1
XFILLER_69_169 vssd1 vccd1 vssd1 vccd1 X2_sky130_ef_sc_hd__decap_40_12
XFILLER_38_545 vssd1 vccd1 vssd1 vccd1 X2_sky130_ef_sc_hd__decap_40_12
XFILLER_84_139 vccd1 vssd1 vccd1 vssd1 X2_sky130_fd_sc_hd__fill_1
XFILLER_38_589 vssd1 vccd1 vccd1 vssd1 X2_sky130_fd_sc_hd__fill_4
XFILLER_80_301 vssd1 vccd1 vccd1 vssd1 X2_sky130_fd_sc_hd__fill_4
Xclkbuf_0_wb_clk_i vssd1 vccd1 vssd1 vccd1 wb_clk_i clkbuf_0_wb_clk_i/X X2_sky130_fd_sc_hd__clkbuf_16
XFILLER_25_217 vssd1 vccd1 vccd1 vssd1 X2_sky130_fd_sc_hd__fill_4
XFILLER_80_345 vssd1 vccd1 vssd1 vccd1 X2_sky130_ef_sc_hd__decap_40_12
XFILLER_33_250 vssd1 vccd1 vssd1 vccd1 X2_sky130_ef_sc_hd__decap_40_12
XFILLER_80_389 vssd1 vccd1 vssd1 vccd1 X2_sky130_ef_sc_hd__decap_40_12
XFILLER_21_445 vssd1 vccd1 vccd1 vssd1 X2_sky130_fd_sc_hd__fill_2
XANTENNA__387__A_N _537_/Q vssd1 vccd1 vccd1 vssd1 X2_sky130_fd_sc_hd__diode_2
XTAP_TAPCELL_ROW_95_1269 vccd1 vssd1 X2_sky130_fd_sc_hd__tapvpwrvgnd_1
XFILLER_0_305 vssd1 vccd1 vccd1 vssd1 X2_sky130_fd_sc_hd__fill_2
XFILLER_88_445 vssd1 vccd1 vssd1 vccd1 X2_sky130_ef_sc_hd__decap_40_12
XFILLER_29_501 vssd1 vccd1 vccd1 vssd1 X2_sky130_fd_sc_hd__fill_2
XFILLER_88_489 vssd1 vccd1 vssd1 vccd1 X2_sky130_ef_sc_hd__decap_40_12
XFILLER_48_309 vssd1 vccd1 vssd1 vccd1 X2_sky130_ef_sc_hd__decap_40_12
XFILLER_84_27 vccd1 vssd1 vccd1 vssd1 X2_sky130_fd_sc_hd__fill_1
XFILLER_90_109 vssd1 vccd1 vssd1 vccd1 X2_sky130_ef_sc_hd__decap_40_12
XFILLER_56_342 vssd1 vccd1 vssd1 vccd1 X2_sky130_ef_sc_hd__decap_40_12
XFILLER_44_515 vssd1 vccd1 vccd1 vssd1 X2_sky130_fd_sc_hd__fill_2
XFILLER_83_161 vssd1 vccd1 vccd1 vssd1 X2_sky130_fd_sc_hd__fill_4
XFILLER_12_401 vssd1 vccd1 vssd1 vccd1 X2_sky130_ef_sc_hd__decap_40_12
XFILLER_71_389 vssd1 vccd1 vccd1 vssd1 X2_sky130_fd_sc_hd__fill_2
XFILLER_52_570 vssd1 vccd1 vssd1 vccd1 X2_sky130_ef_sc_hd__decap_40_12
XFILLER_12_445 vssd1 vccd1 vssd1 vccd1 X2_sky130_ef_sc_hd__decap_40_12
XFILLER_12_489 vssd1 vccd1 vssd1 vccd1 X2_sky130_ef_sc_hd__decap_40_12
XTAP_TAPCELL_ROW_22_462 vccd1 vssd1 X2_sky130_fd_sc_hd__tapvpwrvgnd_1
XTAP_TAPCELL_ROW_50_771 vccd1 vssd1 X2_sky130_fd_sc_hd__tapvpwrvgnd_1
XFILLER_98_209 vssd1 vccd1 vssd1 vccd1 X2_sky130_ef_sc_hd__decap_40_12
XFILLER_3_165 vssd1 vccd1 vccd1 vssd1 X2_sky130_fd_sc_hd__fill_2
XTAP_TAPCELL_ROW_72_1011 vccd1 vssd1 X2_sky130_fd_sc_hd__tapvpwrvgnd_1
XFILLER_79_445 vssd1 vccd1 vccd1 vssd1 X2_sky130_fd_sc_hd__fill_2
XFILLER_58_83 vccd1 vssd1 vccd1 vssd1 X2_sky130_fd_sc_hd__fill_1
Xhold5 hold5/X hold5/A vccd1 vssd1 vssd1 vccd1 X2_sky130_fd_sc_hd__dlygate4sd3_1
XFILLER_66_139 vccd1 vssd1 vccd1 vssd1 X2_sky130_fd_sc_hd__fill_1
XFILLER_81_109 vssd1 vccd1 vccd1 vssd1 X2_sky130_fd_sc_hd__fill_2
XTAP_TAPCELL_ROW_58_860 vccd1 vssd1 X2_sky130_fd_sc_hd__tapvpwrvgnd_1
XFILLER_47_353 vssd1 vccd1 vccd1 vssd1 X2_sky130_fd_sc_hd__fill_2
XFILLER_35_548 vssd1 vccd1 vccd1 vssd1 X2_sky130_fd_sc_hd__fill_2
XANTENNA_clkload3_A _599_/CLK vssd1 vccd1 vccd1 vssd1 X2_sky130_fd_sc_hd__diode_2
XFILLER_62_301 vssd1 vccd1 vccd1 vssd1 X2_sky130_fd_sc_hd__fill_4
XFILLER_62_345 vssd1 vccd1 vssd1 vccd1 X2_sky130_ef_sc_hd__decap_40_12
XFILLER_15_261 vssd1 vccd1 vssd1 vccd1 X2_sky130_ef_sc_hd__decap_40_12
XFILLER_22_209 vssd1 vccd1 vssd1 vccd1 X2_sky130_ef_sc_hd__decap_40_12
XFILLER_62_389 vssd1 vccd1 vssd1 vccd1 X2_sky130_ef_sc_hd__decap_40_12
XFILLER_50_518 vssd1 vccd1 vssd1 vccd1 X2_sky130_ef_sc_hd__decap_40_12
XFILLER_30_253 vssd1 vccd1 vccd1 vssd1 X2_sky130_fd_sc_hd__fill_8
XFILLER_90_81 vssd1 vccd1 vccd1 vssd1 X2_sky130_fd_sc_hd__fill_2
XANTENNA__311__B _317_/B vssd1 vccd1 vccd1 vssd1 X2_sky130_fd_sc_hd__diode_2
XFILLER_72_109 vssd1 vccd1 vssd1 vccd1 X2_sky130_ef_sc_hd__decap_40_12
XFILLER_38_397 vssd1 vccd1 vccd1 vssd1 X2_sky130_fd_sc_hd__fill_8
XFILLER_65_161 vssd1 vccd1 vccd1 vssd1 X2_sky130_fd_sc_hd__fill_4
XFILLER_80_153 vssd1 vccd1 vssd1 vccd1 X2_sky130_ef_sc_hd__decap_40_12
XFILLER_80_197 vssd1 vccd1 vssd1 vccd1 X2_sky130_ef_sc_hd__decap_40_12
XFILLER_70_29 vssd1 vccd1 vssd1 vccd1 X2_sky130_ef_sc_hd__decap_40_12
XFILLER_79_27 vssd1 vccd1 vssd1 vccd1 X2_sky130_ef_sc_hd__decap_40_12
XANTENNA__502__A _527_/A vssd1 vccd1 vccd1 vssd1 X2_sky130_fd_sc_hd__diode_2
XFILLER_0_113 vssd1 vccd1 vssd1 vccd1 X2_sky130_ef_sc_hd__decap_40_12
XFILLER_0_135 vccd1 vssd1 vccd1 vssd1 X2_sky130_fd_sc_hd__fill_1
XFILLER_88_253 vssd1 vccd1 vssd1 vccd1 X2_sky130_ef_sc_hd__decap_40_12
XFILLER_95_15 vssd1 vccd1 vssd1 vccd1 X2_sky130_ef_sc_hd__decap_40_12
XFILLER_48_139 vccd1 vssd1 vccd1 vssd1 X2_sky130_fd_sc_hd__fill_1
XFILLER_28_53 vssd1 vccd1 vssd1 vccd1 X2_sky130_ef_sc_hd__decap_40_12
XFILLER_29_331 vssd1 vccd1 vccd1 vssd1 X2_sky130_fd_sc_hd__fill_4
XFILLER_63_109 vssd1 vccd1 vccd1 vssd1 X2_sky130_fd_sc_hd__fill_2
XFILLER_28_97 vssd1 vccd1 vssd1 vccd1 X2_sky130_ef_sc_hd__decap_40_12
X_562_ vssd1 vccd1 vccd1 vssd1 _597_/CLK _562_/D _482_/Y _562_/Q X2_sky130_fd_sc_hd__dfrtp_1
XFILLER_91_429 vssd1 vccd1 vssd1 vccd1 X2_sky130_ef_sc_hd__decap_40_12
XFILLER_72_621 vssd1 vccd1 vccd1 vssd1 X2_sky130_fd_sc_hd__fill_4
XFILLER_44_301 vssd1 vccd1 vccd1 vssd1 X2_sky130_fd_sc_hd__fill_4
XFILLER_17_559 vccd1 vssd1 vccd1 vssd1 X2_sky130_fd_sc_hd__fill_1
XTAP_TAPCELL_ROW_27_521 vccd1 vssd1 X2_sky130_fd_sc_hd__tapvpwrvgnd_1
XTAP_TAPCELL_ROW_55_830 vccd1 vssd1 X2_sky130_fd_sc_hd__tapvpwrvgnd_1
XFILLER_44_345 vssd1 vccd1 vssd1 vccd1 X2_sky130_ef_sc_hd__decap_40_12
XFILLER_32_529 vssd1 vccd1 vccd1 vssd1 X2_sky130_fd_sc_hd__fill_2
X_493_ vccd1 vssd1 vccd1 vssd1 _493_/Y _517_/A X2_sky130_fd_sc_hd__inv_2
XFILLER_44_389 vssd1 vccd1 vssd1 vccd1 X2_sky130_ef_sc_hd__decap_40_12
XFILLER_44_41 vssd1 vccd1 vssd1 vccd1 X2_sky130_ef_sc_hd__decap_40_12
XPHY_EDGE_ROW_4_Left_106 vccd1 vssd1 vccd1 vssd1 X2_sky130_fd_sc_hd__decap_3
XFILLER_44_85 vssd1 vccd1 vssd1 vccd1 X2_sky130_ef_sc_hd__decap_40_12
XFILLER_12_253 vssd1 vccd1 vssd1 vccd1 X2_sky130_ef_sc_hd__decap_40_12
XFILLER_40_540 vssd1 vccd1 vccd1 vssd1 X2_sky130_fd_sc_hd__fill_8
XFILLER_40_562 vssd1 vccd1 vssd1 vccd1 X2_sky130_ef_sc_hd__decap_40_12
XFILLER_5_57 vssd1 vccd1 vssd1 vccd1 X2_sky130_ef_sc_hd__decap_40_12
XFILLER_99_529 vssd1 vccd1 vssd1 vccd1 X2_sky130_ef_sc_hd__decap_40_12
XFILLER_69_93 vssd1 vccd1 vssd1 vccd1 X2_sky130_ef_sc_hd__decap_40_12
XFILLER_94_245 vssd1 vccd1 vccd1 vssd1 X2_sky130_fd_sc_hd__fill_4
XFILLER_54_109 vssd1 vccd1 vssd1 vccd1 X2_sky130_ef_sc_hd__decap_40_12
XFILLER_94_289 vssd1 vccd1 vccd1 vssd1 X2_sky130_fd_sc_hd__fill_8
XFILLER_85_81 vssd1 vccd1 vssd1 vccd1 X2_sky130_ef_sc_hd__decap_40_12
XFILLER_47_161 vssd1 vccd1 vccd1 vssd1 X2_sky130_fd_sc_hd__fill_4
XFILLER_35_356 vssd1 vccd1 vccd1 vssd1 X2_sky130_fd_sc_hd__fill_2
XFILLER_23_529 vssd1 vccd1 vssd1 vccd1 X2_sky130_ef_sc_hd__decap_40_12
XFILLER_35_389 vssd1 vccd1 vccd1 vssd1 X2_sky130_fd_sc_hd__fill_2
XFILLER_90_473 vssd1 vccd1 vccd1 vssd1 X2_sky130_fd_sc_hd__fill_2
XFILLER_62_153 vssd1 vccd1 vssd1 vccd1 X2_sky130_ef_sc_hd__decap_40_12
XFILLER_16_581 vssd1 vccd1 vccd1 vssd1 X2_sky130_fd_sc_hd__fill_4
XFILLER_62_197 vssd1 vccd1 vccd1 vssd1 X2_sky130_fd_sc_hd__fill_8
XFILLER_50_326 vssd1 vccd1 vssd1 vccd1 X2_sky130_ef_sc_hd__decap_40_12
XTAP_TAPCELL_ROW_33_579 vccd1 vssd1 X2_sky130_fd_sc_hd__tapvpwrvgnd_1
XANTENNA__293__S _299_/S vssd1 vccd1 vccd1 vssd1 X2_sky130_fd_sc_hd__diode_2
XTAP_TAPCELL_ROW_61_888 vccd1 vssd1 X2_sky130_fd_sc_hd__tapvpwrvgnd_1
XTAP_TAPCELL_ROW_92_1228 vccd1 vssd1 X2_sky130_fd_sc_hd__tapvpwrvgnd_1
XFILLER_100_501 vssd1 vccd1 vssd1 vccd1 X2_sky130_ef_sc_hd__decap_40_12
XFILLER_100_545 vssd1 vccd1 vssd1 vccd1 X2_sky130_ef_sc_hd__decap_40_12
XFILLER_85_223 vccd1 vssd1 vccd1 vssd1 X2_sky130_fd_sc_hd__fill_1
XTAP_TAPCELL_ROW_69_977 vccd1 vssd1 X2_sky130_fd_sc_hd__tapvpwrvgnd_1
XFILLER_26_301 vssd1 vccd1 vccd1 vssd1 X2_sky130_fd_sc_hd__fill_4
XFILLER_38_161 vssd1 vccd1 vccd1 vssd1 X2_sky130_fd_sc_hd__fill_2
XFILLER_100_589 vssd1 vccd1 vssd1 vccd1 X2_sky130_ef_sc_hd__decap_40_12
XFILLER_73_429 vssd1 vccd1 vssd1 vccd1 X2_sky130_ef_sc_hd__decap_40_12
XFILLER_45_109 vssd1 vccd1 vccd1 vssd1 X2_sky130_fd_sc_hd__fill_2
XFILLER_26_345 vssd1 vccd1 vssd1 vccd1 X2_sky130_ef_sc_hd__decap_40_12
XFILLER_38_194 vssd1 vccd1 vccd1 vssd1 X2_sky130_fd_sc_hd__fill_2
XPHY_EDGE_ROW_77_Left_179 vccd1 vssd1 vccd1 vssd1 X2_sky130_fd_sc_hd__decap_3
XFILLER_14_529 vssd1 vccd1 vccd1 vssd1 X2_sky130_fd_sc_hd__fill_2
XFILLER_26_389 vssd1 vccd1 vssd1 vccd1 X2_sky130_ef_sc_hd__decap_40_12
XFILLER_81_473 vssd1 vccd1 vssd1 vccd1 X2_sky130_ef_sc_hd__decap_40_12
XFILLER_41_304 vssd1 vccd1 vccd1 vssd1 X2_sky130_fd_sc_hd__fill_8
XFILLER_81_39 vssd1 vccd1 vssd1 vccd1 X2_sky130_ef_sc_hd__decap_40_12
XFILLER_41_337 vccd1 vssd1 vccd1 vssd1 X2_sky130_fd_sc_hd__fill_1
XTAP_TAPCELL_ROW_101_1335 vccd1 vssd1 X2_sky130_fd_sc_hd__tapvpwrvgnd_1
XTAP_TAPCELL_ROW_101_1346 vccd1 vssd1 X2_sky130_fd_sc_hd__tapvpwrvgnd_1
XFILLER_14_77 vssd1 vccd1 vccd1 vssd1 X2_sky130_fd_sc_hd__fill_4
XFILLER_5_205 vssd1 vccd1 vssd1 vccd1 X2_sky130_ef_sc_hd__decap_40_12
XFILLER_5_249 vssd1 vccd1 vssd1 vccd1 X2_sky130_ef_sc_hd__decap_40_12
XFILLER_30_65 vssd1 vccd1 vssd1 vccd1 X2_sky130_ef_sc_hd__decap_40_12
XPHY_EDGE_ROW_86_Left_188 vccd1 vssd1 vccd1 vssd1 X2_sky130_fd_sc_hd__decap_3
XFILLER_100_3 vssd1 vccd1 vssd1 vccd1 X2_sky130_ef_sc_hd__decap_40_12
XFILLER_89_573 vssd1 vccd1 vssd1 vccd1 X2_sky130_ef_sc_hd__decap_40_12
XFILLER_49_415 vssd1 vccd1 vccd1 vssd1 X2_sky130_fd_sc_hd__fill_2
XTAP_TAPCELL_ROW_4_260 vccd1 vssd1 X2_sky130_fd_sc_hd__tapvpwrvgnd_1
XFILLER_76_245 vssd1 vccd1 vccd1 vssd1 X2_sky130_fd_sc_hd__fill_4
XFILLER_64_407 vssd1 vccd1 vssd1 vccd1 X2_sky130_ef_sc_hd__decap_40_12
XANTENNA_input20_A wbs_adr_i[6] vssd1 vccd1 vccd1 vssd1 X2_sky130_fd_sc_hd__diode_2
XFILLER_29_161 vssd1 vccd1 vccd1 vssd1 X2_sky130_fd_sc_hd__fill_4
XFILLER_36_109 vssd1 vccd1 vssd1 vccd1 X2_sky130_ef_sc_hd__decap_40_12
XPHY_EDGE_ROW_95_Left_197 vccd1 vssd1 vccd1 vssd1 X2_sky130_fd_sc_hd__decap_3
XFILLER_45_610 vssd1 vccd1 vccd1 vssd1 X2_sky130_fd_sc_hd__fill_2
XFILLER_91_237 vssd1 vccd1 vssd1 vccd1 X2_sky130_ef_sc_hd__decap_40_12
XFILLER_55_51 vssd1 vccd1 vccd1 vssd1 X2_sky130_fd_sc_hd__fill_4
XFILLER_17_389 vssd1 vccd1 vccd1 vssd1 X2_sky130_fd_sc_hd__fill_2
X_545_ vssd1 vccd1 vccd1 vssd1 _608_/CLK hold5/X _465_/Y _545_/Q X2_sky130_fd_sc_hd__dfrtp_1
XFILLER_72_473 vssd1 vccd1 vccd1 vssd1 X2_sky130_fd_sc_hd__fill_2
XFILLER_44_153 vssd1 vccd1 vssd1 vccd1 X2_sky130_ef_sc_hd__decap_40_12
XFILLER_60_624 vccd1 vssd1 vccd1 vssd1 X2_sky130_fd_sc_hd__fill_1
XFILLER_44_197 vssd1 vccd1 vccd1 vssd1 X2_sky130_fd_sc_hd__fill_2
X_476_ vccd1 vssd1 vccd1 vssd1 _476_/Y _521_/A X2_sky130_fd_sc_hd__inv_2
XFILLER_13_573 vssd1 vccd1 vssd1 vccd1 X2_sky130_ef_sc_hd__decap_40_12
XTAP_TAPCELL_ROW_30_549 vccd1 vssd1 X2_sky130_fd_sc_hd__tapvpwrvgnd_1
XFILLER_99_315 vssd1 vccd1 vccd1 vssd1 X2_sky130_fd_sc_hd__fill_8
XTAP_TAPCELL_ROW_78_1083 vccd1 vssd1 X2_sky130_fd_sc_hd__tapvpwrvgnd_1
XFILLER_99_359 vssd1 vccd1 vccd1 vssd1 X2_sky130_fd_sc_hd__fill_2
XFILLER_99_337 vccd1 vssd1 vccd1 vssd1 X2_sky130_fd_sc_hd__fill_1
XFILLER_101_309 vccd1 vssd1 vccd1 vssd1 X2_sky130_fd_sc_hd__fill_1
XFILLER_67_223 vccd1 vssd1 vccd1 vssd1 X2_sky130_fd_sc_hd__fill_1
XANTENNA__288__S _289_/S vssd1 vccd1 vccd1 vssd1 X2_sky130_fd_sc_hd__diode_2
XFILLER_27_109 vssd1 vccd1 vccd1 vssd1 X2_sky130_fd_sc_hd__fill_2
XFILLER_55_429 vssd1 vccd1 vccd1 vssd1 X2_sky130_fd_sc_hd__fill_4
XTAP_TAPCELL_ROW_38_638 vccd1 vssd1 X2_sky130_fd_sc_hd__tapvpwrvgnd_1
XTAP_TAPCELL_ROW_66_947 vccd1 vssd1 X2_sky130_fd_sc_hd__tapvpwrvgnd_1
XFILLER_63_473 vssd1 vccd1 vccd1 vssd1 X2_sky130_fd_sc_hd__fill_2
XFILLER_23_337 vssd1 vccd1 vssd1 vccd1 X2_sky130_ef_sc_hd__decap_40_12
XANTENNA__317__A _553_/D vssd1 vccd1 vccd1 vssd1 X2_sky130_fd_sc_hd__diode_2
XFILLER_50_189 vssd1 vccd1 vccd1 vssd1 X2_sky130_fd_sc_hd__fill_4
XANTENNA__540__CLK _553_/CLK vssd1 vccd1 vccd1 vssd1 X2_sky130_fd_sc_hd__diode_2
XFILLER_98_381 vssd1 vccd1 vccd1 vssd1 X2_sky130_fd_sc_hd__fill_2
XFILLER_58_245 vssd1 vccd1 vccd1 vssd1 X2_sky130_fd_sc_hd__fill_4
XFILLER_18_109 vssd1 vccd1 vssd1 vccd1 X2_sky130_ef_sc_hd__decap_40_12
XFILLER_86_587 vccd1 vssd1 vccd1 vssd1 X2_sky130_fd_sc_hd__fill_1
XFILLER_100_375 vssd1 vccd1 vccd1 vssd1 X2_sky130_fd_sc_hd__fill_2
XTAP_TAPCELL_ROW_1_230 vccd1 vssd1 X2_sky130_fd_sc_hd__tapvpwrvgnd_1
XFILLER_92_27 vccd1 vssd1 vccd1 vssd1 X2_sky130_fd_sc_hd__fill_1
XFILLER_100_397 vssd1 vccd1 vssd1 vccd1 X2_sky130_ef_sc_hd__decap_40_12
XFILLER_73_237 vssd1 vccd1 vssd1 vccd1 X2_sky130_ef_sc_hd__decap_40_12
XFILLER_26_153 vssd1 vccd1 vssd1 vccd1 X2_sky130_ef_sc_hd__decap_40_12
XFILLER_26_197 vssd1 vccd1 vssd1 vccd1 X2_sky130_ef_sc_hd__decap_40_12
X_330_ vccd1 vssd1 vccd1 vssd1 _320_/X _594_/Q _304_/A _330_/X _586_/Q X2_sky130_fd_sc_hd__a22o_1
XFILLER_81_281 vssd1 vccd1 vssd1 vccd1 X2_sky130_ef_sc_hd__decap_40_12
XFILLER_42_624 vccd1 vssd1 vccd1 vssd1 X2_sky130_fd_sc_hd__fill_1
XFILLER_41_167 vccd1 vssd1 vccd1 vssd1 X2_sky130_fd_sc_hd__fill_1
XFILLER_41_178 vssd1 vccd1 vccd1 vssd1 X2_sky130_fd_sc_hd__fill_2
X_261_ vccd1 vssd1 vccd1 vssd1 _261_/Y _556_/D X2_sky130_fd_sc_hd__inv_2
XFILLER_6_525 vssd1 vccd1 vccd1 vssd1 X2_sky130_fd_sc_hd__fill_4
XFILLER_10_587 vccd1 vssd1 vccd1 vssd1 X2_sky130_fd_sc_hd__fill_1
XFILLER_6_569 vssd1 vccd1 vssd1 vccd1 X2_sky130_ef_sc_hd__decap_40_12
XFILLER_96_307 vccd1 vssd1 vccd1 vssd1 X2_sky130_fd_sc_hd__fill_1
XFILLER_96_318 vssd1 vccd1 vccd1 vssd1 X2_sky130_fd_sc_hd__fill_2
XFILLER_92_513 vssd1 vccd1 vssd1 vccd1 X2_sky130_ef_sc_hd__decap_40_12
XFILLER_92_557 vssd1 vccd1 vssd1 vccd1 X2_sky130_ef_sc_hd__decap_40_12
XFILLER_66_83 vccd1 vssd1 vccd1 vssd1 X2_sky130_fd_sc_hd__fill_1
XTAP_TAPCELL_ROW_35_608 vccd1 vssd1 X2_sky130_fd_sc_hd__tapvpwrvgnd_1
XTAP_TAPCELL_ROW_63_917 vccd1 vssd1 X2_sky130_fd_sc_hd__tapvpwrvgnd_1
XFILLER_45_473 vssd1 vccd1 vccd1 vssd1 X2_sky130_fd_sc_hd__fill_2
XFILLER_33_624 vccd1 vssd1 vccd1 vssd1 X2_sky130_fd_sc_hd__fill_1
XFILLER_60_421 vssd1 vccd1 vssd1 vccd1 X2_sky130_ef_sc_hd__decap_40_12
X_528_ vccd1 vssd1 vccd1 vssd1 _528_/Y _529_/A X2_sky130_fd_sc_hd__inv_2
XFILLER_20_307 vccd1 vssd1 vccd1 vssd1 X2_sky130_fd_sc_hd__fill_1
XFILLER_32_189 vssd1 vccd1 vccd1 vssd1 X2_sky130_fd_sc_hd__fill_4
X_459_ vccd1 vssd1 vccd1 vssd1 _459_/Y _521_/A X2_sky130_fd_sc_hd__inv_2
XTAP_TAPCELL_ROW_15_387 vccd1 vssd1 X2_sky130_fd_sc_hd__tapvpwrvgnd_1
XTAP_TAPCELL_ROW_43_696 vccd1 vssd1 X2_sky130_fd_sc_hd__tapvpwrvgnd_1
XFILLER_9_385 vssd1 vccd1 vccd1 vssd1 X2_sky130_fd_sc_hd__fill_4
XFILLER_63_3 vssd1 vccd1 vssd1 vccd1 X2_sky130_ef_sc_hd__decap_40_12
XFILLER_99_167 vccd1 vssd1 vccd1 vssd1 X2_sky130_fd_sc_hd__fill_1
XFILLER_101_139 vccd1 vssd1 vccd1 vssd1 X2_sky130_fd_sc_hd__fill_1
XFILLER_95_384 vssd1 vccd1 vccd1 vssd1 X2_sky130_fd_sc_hd__fill_8
XFILLER_68_598 vssd1 vccd1 vccd1 vssd1 X2_sky130_fd_sc_hd__fill_2
XFILLER_83_557 vssd1 vccd1 vccd1 vssd1 X2_sky130_fd_sc_hd__fill_2
XFILLER_55_237 vssd1 vccd1 vssd1 vccd1 X2_sky130_ef_sc_hd__decap_40_12
XFILLER_36_451 vssd1 vccd1 vssd1 vccd1 X2_sky130_ef_sc_hd__decap_40_12
XFILLER_24_613 vssd1 vccd1 vssd1 vccd1 X2_sky130_ef_sc_hd__decap_40_12
XFILLER_36_484 vssd1 vccd1 vssd1 vccd1 X2_sky130_ef_sc_hd__decap_40_12
XFILLER_63_281 vccd1 vssd1 vccd1 vssd1 X2_sky130_fd_sc_hd__fill_1
XFILLER_51_443 vssd1 vccd1 vccd1 vssd1 X2_sky130_fd_sc_hd__fill_4
XFILLER_11_329 vssd1 vccd1 vccd1 vssd1 X2_sky130_fd_sc_hd__fill_4
XFILLER_23_167 vccd1 vssd1 vccd1 vssd1 X2_sky130_fd_sc_hd__fill_1
XANTENNA__339__A2 _291_/B vssd1 vccd1 vccd1 vssd1 X2_sky130_fd_sc_hd__diode_2
XFILLER_3_517 vssd1 vccd1 vssd1 vccd1 X2_sky130_ef_sc_hd__decap_40_12
XFILLER_2_7 vssd1 vccd1 vssd1 vccd1 X2_sky130_ef_sc_hd__decap_40_12
XFILLER_87_27 vssd1 vccd1 vssd1 vccd1 X2_sky130_ef_sc_hd__decap_40_12
XFILLER_78_307 vccd1 vssd1 vccd1 vssd1 X2_sky130_fd_sc_hd__fill_1
XANTENNA__510__A _517_/A vssd1 vccd1 vccd1 vssd1 X2_sky130_fd_sc_hd__diode_2
XFILLER_19_429 vssd1 vccd1 vssd1 vccd1 X2_sky130_ef_sc_hd__decap_40_12
XFILLER_74_513 vssd1 vccd1 vssd1 vccd1 X2_sky130_ef_sc_hd__decap_40_12
XFILLER_46_204 vssd1 vccd1 vccd1 vssd1 X2_sky130_fd_sc_hd__fill_2
XFILLER_74_557 vssd1 vccd1 vccd1 vssd1 X2_sky130_fd_sc_hd__fill_8
XFILLER_36_53 vssd1 vccd1 vssd1 vccd1 X2_sky130_ef_sc_hd__decap_40_12
XFILLER_15_613 vssd1 vccd1 vccd1 vssd1 X2_sky130_fd_sc_hd__fill_2
XFILLER_27_473 vssd1 vccd1 vssd1 vccd1 X2_sky130_ef_sc_hd__decap_40_12
XFILLER_36_97 vssd1 vccd1 vssd1 vccd1 X2_sky130_ef_sc_hd__decap_40_12
XFILLER_54_270 vssd1 vccd1 vccd1 vssd1 X2_sky130_fd_sc_hd__fill_8
XFILLER_42_421 vccd1 vssd1 vccd1 vssd1 X2_sky130_fd_sc_hd__fill_1
XFILLER_14_189 vssd1 vccd1 vccd1 vssd1 X2_sky130_fd_sc_hd__fill_4
X_313_ vssd1 vccd1 _313_/X _317_/B _555_/D _317_/C vccd1 vssd1 X2_sky130_fd_sc_hd__and3_1
XFILLER_52_41 vssd1 vccd1 vssd1 vccd1 X2_sky130_ef_sc_hd__decap_40_12
XFILLER_52_85 vssd1 vccd1 vssd1 vccd1 X2_sky130_ef_sc_hd__decap_40_12
XTAP_TAPCELL_ROW_12_357 vccd1 vssd1 X2_sky130_fd_sc_hd__tapvpwrvgnd_1
XTAP_TAPCELL_ROW_40_655 vccd1 vssd1 X2_sky130_fd_sc_hd__tapvpwrvgnd_1
Xinput28 vssd1 vccd1 _275_/A0 wbs_dat_i[14] vccd1 vssd1 X2_sky130_fd_sc_hd__clkbuf_1
Xinput17 vssd1 vccd1 _320_/A wbs_adr_i[3] vccd1 vssd1 X2_sky130_fd_sc_hd__buf_1
XFILLER_6_333 vssd1 vccd1 vssd1 vccd1 X2_sky130_ef_sc_hd__decap_40_12
Xinput39 vssd1 vccd1 _266_/A wbs_stb_i vccd1 vssd1 X2_sky130_fd_sc_hd__buf_1
XFILLER_6_377 vssd1 vccd1 vssd1 vccd1 X2_sky130_ef_sc_hd__decap_40_12
XTAP_TAPCELL_ROW_75_1042 vccd1 vssd1 X2_sky130_fd_sc_hd__tapvpwrvgnd_1
XFILLER_35_7 vssd1 vccd1 vccd1 vssd1 X2_sky130_fd_sc_hd__fill_2
XFILLER_69_329 vssd1 vccd1 vccd1 vssd1 X2_sky130_fd_sc_hd__fill_2
XFILLER_96_137 vssd1 vccd1 vccd1 vssd1 X2_sky130_fd_sc_hd__fill_2
XFILLER_77_373 vssd1 vccd1 vssd1 vccd1 X2_sky130_ef_sc_hd__decap_40_12
XFILLER_77_93 vssd1 vccd1 vssd1 vccd1 X2_sky130_ef_sc_hd__decap_40_12
XFILLER_65_502 vssd1 vccd1 vccd1 vssd1 X2_sky130_fd_sc_hd__fill_2
XFILLER_65_557 vssd1 vccd1 vccd1 vssd1 X2_sky130_fd_sc_hd__fill_2
XTAP_TAPCELL_ROW_48_744 vccd1 vssd1 X2_sky130_fd_sc_hd__tapvpwrvgnd_1
XFILLER_37_259 vssd1 vccd1 vssd1 vccd1 X2_sky130_ef_sc_hd__decap_40_12
XFILLER_92_365 vssd1 vccd1 vssd1 vccd1 X2_sky130_ef_sc_hd__decap_40_12
XFILLER_65_579 vssd1 vccd1 vssd1 vccd1 X2_sky130_ef_sc_hd__decap_40_12
XFILLER_52_207 vssd1 vccd1 vccd1 vssd1 X2_sky130_fd_sc_hd__fill_2
XFILLER_18_473 vssd1 vccd1 vccd1 vssd1 X2_sky130_fd_sc_hd__fill_2
XTAP_TAPCELL_ROW_86_1171 vccd1 vssd1 X2_sky130_fd_sc_hd__tapvpwrvgnd_1
XFILLER_93_81 vssd1 vccd1 vssd1 vccd1 X2_sky130_ef_sc_hd__decap_40_12
XFILLER_45_281 vccd1 vssd1 vccd1 vssd1 X2_sky130_fd_sc_hd__fill_1
XFILLER_33_443 vssd1 vccd1 vccd1 vssd1 X2_sky130_fd_sc_hd__fill_4
XFILLER_60_251 vccd1 vssd1 vccd1 vssd1 X2_sky130_fd_sc_hd__fill_1
XFILLER_20_137 vssd1 vccd1 vccd1 vssd1 X2_sky130_fd_sc_hd__fill_2
XFILLER_9_193 vssd1 vccd1 vssd1 vccd1 X2_sky130_ef_sc_hd__decap_40_12
XFILLER_87_137 vssd1 vccd1 vssd1 vccd1 X2_sky130_ef_sc_hd__decap_40_12
XFILLER_56_513 vssd1 vccd1 vssd1 vccd1 X2_sky130_ef_sc_hd__decap_40_12
XFILLER_95_181 vssd1 vccd1 vssd1 vccd1 X2_sky130_ef_sc_hd__decap_40_12
XFILLER_56_557 vssd1 vccd1 vssd1 vccd1 X2_sky130_ef_sc_hd__decap_40_12
XFILLER_71_505 vssd1 vccd1 vssd1 vccd1 X2_sky130_ef_sc_hd__decap_40_12
XFILLER_24_421 vssd1 vccd1 vssd1 vccd1 X2_sky130_ef_sc_hd__decap_40_12
XFILLER_11_137 vssd1 vccd1 vssd1 vccd1 X2_sky130_ef_sc_hd__decap_40_12
XANTENNA__505__A _527_/A vssd1 vccd1 vccd1 vssd1 X2_sky130_fd_sc_hd__diode_2
XFILLER_22_77 vssd1 vccd1 vccd1 vssd1 X2_sky130_fd_sc_hd__fill_4
XFILLER_98_15 vssd1 vccd1 vssd1 vccd1 X2_sky130_ef_sc_hd__decap_40_12
XFILLER_78_137 vssd1 vccd1 vccd1 vssd1 X2_sky130_fd_sc_hd__fill_2
XFILLER_59_373 vssd1 vccd1 vssd1 vccd1 X2_sky130_ef_sc_hd__decap_40_12
XFILLER_19_237 vssd1 vccd1 vssd1 vccd1 X2_sky130_ef_sc_hd__decap_40_12
XFILLER_74_321 vssd1 vccd1 vssd1 vccd1 X2_sky130_ef_sc_hd__decap_40_12
XFILLER_74_365 vssd1 vccd1 vssd1 vccd1 X2_sky130_ef_sc_hd__decap_40_12
XFILLER_47_557 vssd1 vccd1 vccd1 vssd1 X2_sky130_fd_sc_hd__fill_2
XTAP_TAPCELL_ROW_17_405 vccd1 vssd1 X2_sky130_fd_sc_hd__tapvpwrvgnd_1
XFILLER_34_229 vssd1 vccd1 vccd1 vssd1 X2_sky130_fd_sc_hd__fill_2
XTAP_TAPCELL_ROW_45_714 vccd1 vssd1 X2_sky130_fd_sc_hd__tapvpwrvgnd_1
XFILLER_27_281 vssd1 vccd1 vssd1 vccd1 X2_sky130_ef_sc_hd__decap_40_12
XFILLER_63_51 vssd1 vccd1 vccd1 vssd1 X2_sky130_fd_sc_hd__fill_4
XFILLER_55_590 vssd1 vccd1 vssd1 vccd1 X2_sky130_ef_sc_hd__decap_40_12
XFILLER_30_413 vssd1 vccd1 vccd1 vssd1 X2_sky130_fd_sc_hd__fill_4
XFILLER_42_251 vccd1 vssd1 vccd1 vssd1 X2_sky130_fd_sc_hd__fill_1
XTAP_TAPCELL_ROW_25_493 vccd1 vssd1 X2_sky130_fd_sc_hd__tapvpwrvgnd_1
XFILLER_30_457 vssd1 vccd1 vssd1 vccd1 X2_sky130_ef_sc_hd__decap_40_12
XANTENNA__601__CLK _601_/CLK vssd1 vccd1 vccd1 vssd1 X2_sky130_fd_sc_hd__diode_2
XFILLER_6_141 vssd1 vccd1 vssd1 vccd1 X2_sky130_ef_sc_hd__decap_40_12
XFILLER_88_81 vssd1 vccd1 vccd1 vssd1 X2_sky130_fd_sc_hd__fill_2
Xtop_soc_72 wbs_dat_o[20] top_soc_72/HI vccd1 vssd1 vssd1 vccd1 X2_sky130_fd_sc_hd__conb_1
Xtop_soc_83 wbs_dat_o[31] top_soc_83/HI vccd1 vssd1 vssd1 vccd1 X2_sky130_fd_sc_hd__conb_1
XFILLER_69_137 vssd1 vccd1 vssd1 vccd1 X2_sky130_ef_sc_hd__decap_40_12
XFILLER_26_3 vssd1 vccd1 vssd1 vccd1 X2_sky130_ef_sc_hd__decap_40_12
XFILLER_77_181 vssd1 vccd1 vssd1 vccd1 X2_sky130_ef_sc_hd__decap_40_12
XANTENNA__296__S _299_/S vssd1 vccd1 vccd1 vssd1 X2_sky130_fd_sc_hd__diode_2
XFILLER_38_557 vssd1 vccd1 vssd1 vccd1 X2_sky130_ef_sc_hd__decap_40_12
XFILLER_53_505 vssd1 vccd1 vssd1 vccd1 X2_sky130_ef_sc_hd__decap_40_12
XFILLER_92_195 vccd1 vssd1 vccd1 vssd1 X2_sky130_fd_sc_hd__fill_1
XFILLER_80_357 vssd1 vccd1 vccd1 vssd1 X2_sky130_fd_sc_hd__fill_4
XFILLER_33_240 vssd1 vccd1 vccd1 vssd1 X2_sky130_fd_sc_hd__fill_2
XFILLER_33_262 vssd1 vccd1 vssd1 vccd1 X2_sky130_ef_sc_hd__decap_40_12
XFILLER_61_571 vccd1 vssd1 vccd1 vssd1 X2_sky130_fd_sc_hd__fill_1
XFILLER_33_295 vssd1 vccd1 vccd1 vssd1 X2_sky130_fd_sc_hd__fill_2
XFILLER_0_317 vccd1 vssd1 vccd1 vssd1 X2_sky130_fd_sc_hd__fill_1
XFILLER_68_29 vssd1 vccd1 vssd1 vccd1 X2_sky130_ef_sc_hd__decap_40_12
XFILLER_88_457 vssd1 vccd1 vssd1 vccd1 X2_sky130_ef_sc_hd__decap_40_12
XFILLER_56_332 vssd1 vccd1 vccd1 vssd1 X2_sky130_fd_sc_hd__fill_2
XFILLER_56_321 vssd1 vccd1 vccd1 vssd1 X2_sky130_fd_sc_hd__fill_2
XFILLER_29_557 vssd1 vccd1 vccd1 vssd1 X2_sky130_fd_sc_hd__fill_2
XFILLER_56_365 vssd1 vccd1 vssd1 vccd1 X2_sky130_ef_sc_hd__decap_40_12
XFILLER_56_354 vssd1 vccd1 vccd1 vssd1 X2_sky130_fd_sc_hd__fill_8
XFILLER_44_505 vssd1 vccd1 vccd1 vssd1 X2_sky130_fd_sc_hd__fill_2
XFILLER_17_55 vccd1 vssd1 vccd1 vssd1 X2_sky130_fd_sc_hd__fill_1
XFILLER_71_335 vccd1 vssd1 vccd1 vssd1 X2_sky130_fd_sc_hd__fill_1
XFILLER_24_251 vccd1 vssd1 vccd1 vssd1 X2_sky130_fd_sc_hd__fill_1
XFILLER_12_413 vssd1 vccd1 vccd1 vssd1 X2_sky130_fd_sc_hd__fill_4
XFILLER_52_582 vssd1 vccd1 vccd1 vssd1 X2_sky130_fd_sc_hd__fill_4
XFILLER_8_417 vssd1 vccd1 vccd1 vssd1 X2_sky130_fd_sc_hd__fill_2
XFILLER_12_457 vssd1 vccd1 vssd1 vccd1 X2_sky130_ef_sc_hd__decap_40_12
XTAP_TAPCELL_ROW_22_463 vccd1 vssd1 X2_sky130_fd_sc_hd__tapvpwrvgnd_1
XTAP_TAPCELL_ROW_50_772 vccd1 vssd1 X2_sky130_fd_sc_hd__tapvpwrvgnd_1
XFILLER_4_601 vssd1 vccd1 vssd1 vccd1 X2_sky130_ef_sc_hd__decap_40_12
XFILLER_3_111 vccd1 vssd1 vccd1 vssd1 X2_sky130_fd_sc_hd__fill_1
XTAP_TAPCELL_ROW_72_1012 vccd1 vssd1 X2_sky130_fd_sc_hd__tapvpwrvgnd_1
XFILLER_67_619 vccd1 vssd1 vccd1 vssd1 X2_sky130_fd_sc_hd__fill_1
Xhold6 hold6/X hold6/A vccd1 vssd1 vssd1 vccd1 X2_sky130_fd_sc_hd__dlygate4sd3_1
XFILLER_59_181 vssd1 vccd1 vssd1 vccd1 X2_sky130_ef_sc_hd__decap_40_12
XFILLER_47_321 vssd1 vccd1 vssd1 vccd1 X2_sky130_ef_sc_hd__decap_40_12
XFILLER_47_310 vccd1 vssd1 vccd1 vssd1 X2_sky130_fd_sc_hd__fill_1
XFILLER_35_505 vssd1 vccd1 vssd1 vccd1 X2_sky130_ef_sc_hd__decap_40_12
XTAP_TAPCELL_ROW_58_861 vccd1 vssd1 X2_sky130_fd_sc_hd__tapvpwrvgnd_1
XFILLER_47_398 vssd1 vccd1 vccd1 vssd1 X2_sky130_fd_sc_hd__fill_4
XFILLER_47_376 vssd1 vccd1 vssd1 vccd1 X2_sky130_ef_sc_hd__decap_40_12
XTAP_TAPCELL_ROW_83_1130 vccd1 vssd1 X2_sky130_fd_sc_hd__tapvpwrvgnd_1
XFILLER_74_195 vccd1 vssd1 vccd1 vssd1 X2_sky130_fd_sc_hd__fill_1
XFILLER_74_83 vccd1 vssd1 vccd1 vssd1 X2_sky130_fd_sc_hd__fill_1
XFILLER_62_357 vssd1 vccd1 vccd1 vssd1 X2_sky130_fd_sc_hd__fill_4
XFILLER_15_273 vssd1 vccd1 vccd1 vssd1 X2_sky130_fd_sc_hd__fill_4
XFILLER_30_221 vssd1 vccd1 vssd1 vccd1 X2_sky130_ef_sc_hd__decap_40_12
XFILLER_7_461 vssd1 vccd1 vssd1 vccd1 X2_sky130_ef_sc_hd__decap_40_12
XFILLER_97_221 vssd1 vccd1 vccd1 vssd1 X2_sky130_fd_sc_hd__fill_2
XANTENNA__311__C _317_/C vssd1 vccd1 vccd1 vssd1 X2_sky130_fd_sc_hd__diode_2
XFILLER_85_405 vssd1 vccd1 vssd1 vccd1 X2_sky130_ef_sc_hd__decap_40_12
XFILLER_58_619 vssd1 vccd1 vccd1 vssd1 X2_sky130_fd_sc_hd__fill_2
XFILLER_85_449 vssd1 vccd1 vssd1 vccd1 X2_sky130_ef_sc_hd__decap_40_12
XFILLER_38_365 vccd1 vssd1 vccd1 vssd1 X2_sky130_fd_sc_hd__fill_1
XFILLER_38_387 vssd1 vccd1 vccd1 vssd1 X2_sky130_fd_sc_hd__fill_2
XFILLER_80_121 vssd1 vccd1 vssd1 vccd1 X2_sky130_ef_sc_hd__decap_40_12
XFILLER_53_357 vssd1 vccd1 vccd1 vssd1 X2_sky130_fd_sc_hd__fill_2
XFILLER_53_335 vccd1 vssd1 vccd1 vssd1 X2_sky130_fd_sc_hd__fill_1
XFILLER_80_165 vssd1 vccd1 vssd1 vccd1 X2_sky130_ef_sc_hd__decap_40_12
XFILLER_53_379 vssd1 vccd1 vccd1 vssd1 X2_sky130_fd_sc_hd__fill_2
XFILLER_21_221 vssd1 vccd1 vccd1 vssd1 X2_sky130_fd_sc_hd__fill_2
XFILLER_34_593 vccd1 vssd1 vccd1 vssd1 X2_sky130_fd_sc_hd__fill_1
XPHY_EDGE_ROW_3_Right_3 vccd1 vssd1 vccd1 vssd1 X2_sky130_fd_sc_hd__decap_3
XFILLER_79_39 vssd1 vccd1 vssd1 vccd1 X2_sky130_ef_sc_hd__decap_40_12
XFILLER_1_615 vccd1 vssd1 vccd1 vssd1 X2_sky130_fd_sc_hd__fill_1
XFILLER_0_125 vssd1 vccd1 vccd1 vssd1 X2_sky130_fd_sc_hd__fill_8
XFILLER_88_221 vssd1 vccd1 vssd1 vccd1 X2_sky130_ef_sc_hd__decap_40_12
XFILLER_0_169 vssd1 vccd1 vssd1 vccd1 X2_sky130_ef_sc_hd__decap_40_12
XFILLER_88_265 vssd1 vccd1 vssd1 vccd1 X2_sky130_ef_sc_hd__decap_40_12
XFILLER_95_27 vssd1 vccd1 vssd1 vccd1 X2_sky130_ef_sc_hd__decap_40_12
XFILLER_28_65 vssd1 vccd1 vssd1 vccd1 X2_sky130_ef_sc_hd__decap_40_12
XFILLER_17_505 vssd1 vccd1 vssd1 vccd1 X2_sky130_ef_sc_hd__decap_40_12
X_561_ vssd1 vccd1 vccd1 vssd1 _597_/CLK _561_/D _481_/Y _561_/Q X2_sky130_fd_sc_hd__dfrtp_1
XTAP_TAPCELL_ROW_27_522 vccd1 vssd1 X2_sky130_fd_sc_hd__tapvpwrvgnd_1
XFILLER_56_195 vccd1 vssd1 vccd1 vssd1 X2_sky130_fd_sc_hd__fill_1
XTAP_TAPCELL_ROW_55_820 vccd1 vssd1 X2_sky130_fd_sc_hd__tapvpwrvgnd_1
XFILLER_44_357 vssd1 vccd1 vccd1 vssd1 X2_sky130_fd_sc_hd__fill_4
XFILLER_71_165 vssd1 vccd1 vccd1 vssd1 X2_sky130_fd_sc_hd__fill_2
X_492_ vccd1 vssd1 vccd1 vssd1 _492_/Y _517_/A X2_sky130_fd_sc_hd__inv_2
XFILLER_44_53 vssd1 vccd1 vssd1 vccd1 X2_sky130_ef_sc_hd__decap_40_12
XFILLER_12_221 vssd1 vccd1 vssd1 vccd1 X2_sky130_ef_sc_hd__decap_40_12
XFILLER_44_97 vssd1 vccd1 vssd1 vccd1 X2_sky130_ef_sc_hd__decap_40_12
XFILLER_12_265 vssd1 vccd1 vssd1 vccd1 X2_sky130_ef_sc_hd__decap_40_12
XFILLER_40_574 vssd1 vccd1 vssd1 vccd1 X2_sky130_ef_sc_hd__decap_40_12
XFILLER_100_81 vssd1 vccd1 vccd1 vssd1 X2_sky130_fd_sc_hd__fill_2
XFILLER_60_41 vssd1 vccd1 vssd1 vccd1 X2_sky130_ef_sc_hd__decap_40_12
XFILLER_60_85 vssd1 vccd1 vssd1 vccd1 X2_sky130_ef_sc_hd__decap_40_12
XFILLER_4_475 vccd1 vssd1 vccd1 vssd1 X2_sky130_fd_sc_hd__fill_1
XFILLER_5_69 vssd1 vccd1 vssd1 vccd1 X2_sky130_ef_sc_hd__decap_40_12
XFILLER_79_221 vssd1 vccd1 vccd1 vssd1 X2_sky130_fd_sc_hd__fill_2
XFILLER_67_405 vssd1 vccd1 vssd1 vccd1 X2_sky130_ef_sc_hd__decap_40_12
XFILLER_67_449 vssd1 vccd1 vssd1 vccd1 X2_sky130_ef_sc_hd__decap_40_12
XFILLER_85_93 vssd1 vccd1 vssd1 vccd1 X2_sky130_ef_sc_hd__decap_40_12
XFILLER_82_419 vccd1 vssd1 vccd1 vssd1 X2_sky130_fd_sc_hd__fill_1
XFILLER_35_335 vccd1 vssd1 vccd1 vssd1 X2_sky130_fd_sc_hd__fill_1
XFILLER_35_346 vssd1 vccd1 vccd1 vssd1 X2_sky130_fd_sc_hd__fill_2
XFILLER_62_121 vssd1 vccd1 vssd1 vccd1 X2_sky130_ef_sc_hd__decap_40_12
XFILLER_35_368 vssd1 vccd1 vccd1 vssd1 X2_sky130_fd_sc_hd__fill_4
XFILLER_62_165 vssd1 vccd1 vssd1 vccd1 X2_sky130_ef_sc_hd__decap_40_12
XFILLER_50_338 vssd1 vccd1 vssd1 vccd1 X2_sky130_ef_sc_hd__decap_40_12
XFILLER_31_541 vssd1 vccd1 vssd1 vccd1 X2_sky130_ef_sc_hd__decap_40_12
XFILLER_93_3 vssd1 vccd1 vssd1 vccd1 X2_sky130_ef_sc_hd__decap_40_12
XFILLER_43_390 vssd1 vccd1 vccd1 vssd1 X2_sky130_fd_sc_hd__fill_2
XTAP_TAPCELL_ROW_61_889 vccd1 vssd1 X2_sky130_fd_sc_hd__tapvpwrvgnd_1
XTAP_TAPCELL_ROW_92_1229 vccd1 vssd1 X2_sky130_fd_sc_hd__tapvpwrvgnd_1
XFILLER_100_513 vssd1 vccd1 vssd1 vccd1 X2_sky130_ef_sc_hd__decap_40_12
XFILLER_98_585 vssd1 vccd1 vccd1 vssd1 X2_sky130_fd_sc_hd__fill_2
XFILLER_100_557 vssd1 vccd1 vssd1 vccd1 X2_sky130_ef_sc_hd__decap_40_12
XTAP_TAPCELL_ROW_69_978 vccd1 vssd1 X2_sky130_fd_sc_hd__tapvpwrvgnd_1
XFILLER_85_279 vccd1 vssd1 vccd1 vssd1 X2_sky130_fd_sc_hd__fill_1
XFILLER_81_441 vssd1 vccd1 vccd1 vssd1 X2_sky130_fd_sc_hd__fill_4
XFILLER_26_357 vssd1 vccd1 vccd1 vssd1 X2_sky130_fd_sc_hd__fill_4
XFILLER_53_165 vssd1 vccd1 vccd1 vssd1 X2_sky130_fd_sc_hd__fill_2
XFILLER_81_485 vssd1 vccd1 vssd1 vccd1 X2_sky130_ef_sc_hd__decap_40_12
XTAP_TAPCELL_ROW_101_1336 vccd1 vssd1 X2_sky130_fd_sc_hd__tapvpwrvgnd_1
XTAP_TAPCELL_ROW_101_1347 vccd1 vssd1 X2_sky130_fd_sc_hd__tapvpwrvgnd_1
XFILLER_22_585 vssd1 vccd1 vccd1 vssd1 X2_sky130_fd_sc_hd__fill_2
XFILLER_5_217 vssd1 vccd1 vccd1 vssd1 X2_sky130_fd_sc_hd__fill_4
XANTENNA__513__A _527_/A vssd1 vccd1 vccd1 vssd1 X2_sky130_fd_sc_hd__diode_2
XFILLER_30_77 vssd1 vccd1 vccd1 vssd1 X2_sky130_fd_sc_hd__fill_4
XFILLER_89_541 vssd1 vccd1 vssd1 vccd1 X2_sky130_ef_sc_hd__decap_40_12
XFILLER_1_445 vssd1 vccd1 vccd1 vssd1 X2_sky130_fd_sc_hd__fill_2
XFILLER_89_585 vssd1 vccd1 vssd1 vccd1 X2_sky130_ef_sc_hd__decap_40_12
XFILLER_49_449 vccd1 vssd1 vccd1 vssd1 X2_sky130_fd_sc_hd__fill_1
XFILLER_49_427 vccd1 vssd1 vccd1 vssd1 X2_sky130_fd_sc_hd__fill_1
XFILLER_76_257 vccd1 vssd1 vccd1 vssd1 X2_sky130_fd_sc_hd__fill_1
XTAP_TAPCELL_ROW_4_261 vccd1 vssd1 X2_sky130_fd_sc_hd__tapvpwrvgnd_1
XFILLER_91_205 vssd1 vccd1 vssd1 vccd1 X2_sky130_ef_sc_hd__decap_40_12
XFILLER_64_419 vccd1 vssd1 vccd1 vssd1 X2_sky130_fd_sc_hd__fill_1
XFILLER_45_600 vssd1 vccd1 vccd1 vssd1 X2_sky130_fd_sc_hd__fill_2
XFILLER_17_335 vccd1 vssd1 vccd1 vssd1 X2_sky130_fd_sc_hd__fill_1
XANTENNA_input13_A wb_rst_i vssd1 vccd1 vccd1 vssd1 X2_sky130_fd_sc_hd__diode_2
XFILLER_91_249 vssd1 vccd1 vssd1 vccd1 X2_sky130_ef_sc_hd__decap_40_12
XFILLER_44_121 vssd1 vccd1 vssd1 vccd1 X2_sky130_ef_sc_hd__decap_40_12
XFILLER_32_305 vssd1 vccd1 vccd1 vssd1 X2_sky130_fd_sc_hd__fill_2
X_544_ vssd1 vccd1 vccd1 vssd1 _607_/CLK _544_/D _464_/Y _544_/Q X2_sky130_fd_sc_hd__dfrtp_1
XFILLER_44_165 vssd1 vccd1 vssd1 vccd1 X2_sky130_ef_sc_hd__decap_40_12
XTAP_TAPCELL_ROW_80_1100 vccd1 vssd1 X2_sky130_fd_sc_hd__tapvpwrvgnd_1
X_475_ vccd1 vssd1 vccd1 vssd1 _475_/Y _521_/A X2_sky130_fd_sc_hd__inv_2
XFILLER_9_501 vssd1 vccd1 vccd1 vssd1 X2_sky130_fd_sc_hd__fill_2
XFILLER_13_541 vssd1 vccd1 vssd1 vccd1 X2_sky130_ef_sc_hd__decap_40_12
XFILLER_13_585 vssd1 vccd1 vssd1 vccd1 X2_sky130_ef_sc_hd__decap_40_12
XFILLER_40_360 vssd1 vccd1 vccd1 vssd1 X2_sky130_fd_sc_hd__fill_4
XFILLER_71_51 vssd1 vccd1 vccd1 vssd1 X2_sky130_fd_sc_hd__fill_4
XFILLER_99_305 vssd1 vccd1 vccd1 vssd1 X2_sky130_fd_sc_hd__fill_2
XTAP_TAPCELL_ROW_78_1073 vccd1 vssd1 X2_sky130_fd_sc_hd__tapvpwrvgnd_1
XFILLER_96_81 vssd1 vccd1 vccd1 vssd1 X2_sky130_fd_sc_hd__fill_2
XFILLER_67_279 vccd1 vssd1 vccd1 vssd1 X2_sky130_fd_sc_hd__fill_1
XTAP_TAPCELL_ROW_38_639 vccd1 vssd1 X2_sky130_fd_sc_hd__tapvpwrvgnd_1
XFILLER_82_249 vssd1 vccd1 vccd1 vssd1 X2_sky130_fd_sc_hd__fill_2
XTAP_TAPCELL_ROW_66_948 vccd1 vssd1 X2_sky130_fd_sc_hd__tapvpwrvgnd_1
XFILLER_23_305 vssd1 vccd1 vssd1 vccd1 X2_sky130_ef_sc_hd__decap_40_12
XFILLER_35_165 vssd1 vccd1 vccd1 vssd1 X2_sky130_fd_sc_hd__fill_2
XFILLER_63_441 vssd1 vccd1 vccd1 vssd1 X2_sky130_fd_sc_hd__fill_4
XFILLER_90_293 vssd1 vccd1 vccd1 vssd1 X2_sky130_fd_sc_hd__fill_8
XFILLER_23_349 vssd1 vccd1 vssd1 vccd1 X2_sky130_ef_sc_hd__decap_40_12
XANTENNA__317__B _317_/B vssd1 vccd1 vccd1 vssd1 X2_sky130_fd_sc_hd__diode_2
XFILLER_31_393 vssd1 vccd1 vssd1 vccd1 X2_sky130_ef_sc_hd__decap_40_12
XFILLER_2_209 vssd1 vccd1 vssd1 vccd1 X2_sky130_ef_sc_hd__decap_40_12
XANTENNA_input5_A adc_data_in[2] vssd1 vccd1 vccd1 vssd1 X2_sky130_fd_sc_hd__diode_2
XFILLER_86_533 vssd1 vccd1 vssd1 vccd1 X2_sky130_ef_sc_hd__decap_40_12
XFILLER_98_393 vssd1 vccd1 vccd1 vssd1 X2_sky130_fd_sc_hd__fill_2
XFILLER_76_29 vssd1 vccd1 vssd1 vccd1 X2_sky130_ef_sc_hd__decap_40_12
XFILLER_100_332 vssd1 vccd1 vccd1 vssd1 X2_sky130_fd_sc_hd__fill_4
XFILLER_100_365 vssd1 vccd1 vccd1 vssd1 X2_sky130_fd_sc_hd__fill_2
XFILLER_73_205 vssd1 vccd1 vssd1 vccd1 X2_sky130_ef_sc_hd__decap_40_12
XFILLER_58_279 vccd1 vssd1 vccd1 vssd1 X2_sky130_fd_sc_hd__fill_1
XFILLER_58_268 vssd1 vccd1 vccd1 vssd1 X2_sky130_fd_sc_hd__fill_2
XTAP_TAPCELL_ROW_1_231 vccd1 vssd1 X2_sky130_fd_sc_hd__tapvpwrvgnd_1
XFILLER_26_121 vssd1 vccd1 vssd1 vccd1 X2_sky130_ef_sc_hd__decap_40_12
XFILLER_73_249 vssd1 vccd1 vssd1 vccd1 X2_sky130_ef_sc_hd__decap_40_12
XFILLER_14_305 vssd1 vccd1 vccd1 vssd1 X2_sky130_fd_sc_hd__fill_2
XFILLER_26_165 vssd1 vccd1 vssd1 vccd1 X2_sky130_ef_sc_hd__decap_40_12
XANTENNA__508__A _527_/A vssd1 vccd1 vccd1 vssd1 X2_sky130_fd_sc_hd__diode_2
XFILLER_41_113 vssd1 vccd1 vssd1 vccd1 X2_sky130_ef_sc_hd__decap_40_12
XFILLER_42_614 vssd1 vccd1 vccd1 vssd1 X2_sky130_fd_sc_hd__fill_2
XFILLER_25_55 vccd1 vssd1 vccd1 vssd1 X2_sky130_fd_sc_hd__fill_1
XFILLER_81_293 vssd1 vccd1 vssd1 vccd1 X2_sky130_ef_sc_hd__decap_40_12
X_260_ vccd1 vssd1 vccd1 vssd1 _356_/A _540_/Q X2_sky130_fd_sc_hd__inv_2
XFILLER_10_533 vssd1 vccd1 vssd1 vccd1 X2_sky130_ef_sc_hd__decap_40_12
XTAP_TAPCELL_ROW_9_320 vccd1 vssd1 X2_sky130_fd_sc_hd__tapvpwrvgnd_1
XFILLER_89_393 vssd1 vccd1 vssd1 vccd1 X2_sky130_ef_sc_hd__decap_40_12
XFILLER_92_525 vssd1 vccd1 vccd1 vssd1 X2_sky130_fd_sc_hd__fill_4
XFILLER_49_279 vccd1 vssd1 vccd1 vssd1 X2_sky130_fd_sc_hd__fill_1
XFILLER_64_249 vssd1 vccd1 vccd1 vssd1 X2_sky130_fd_sc_hd__fill_2
XFILLER_33_603 vssd1 vccd1 vccd1 vssd1 X2_sky130_fd_sc_hd__fill_2
XTAP_TAPCELL_ROW_35_609 vccd1 vssd1 X2_sky130_fd_sc_hd__tapvpwrvgnd_1
XFILLER_92_569 vssd1 vccd1 vssd1 vccd1 X2_sky130_ef_sc_hd__decap_40_12
XTAP_TAPCELL_ROW_63_918 vccd1 vssd1 X2_sky130_fd_sc_hd__tapvpwrvgnd_1
XFILLER_17_165 vssd1 vccd1 vccd1 vssd1 X2_sky130_fd_sc_hd__fill_2
X_527_ vccd1 vssd1 vccd1 vssd1 _527_/Y _527_/A X2_sky130_fd_sc_hd__inv_2
XFILLER_82_83 vccd1 vssd1 vccd1 vssd1 X2_sky130_fd_sc_hd__fill_1
XFILLER_60_433 vssd1 vccd1 vssd1 vccd1 X2_sky130_ef_sc_hd__decap_40_12
X_458_ vccd1 vssd1 vccd1 vssd1 _458_/Y _521_/A X2_sky130_fd_sc_hd__inv_2
XFILLER_60_477 vssd1 vccd1 vssd1 vccd1 X2_sky130_ef_sc_hd__decap_40_12
XFILLER_13_393 vssd1 vccd1 vssd1 vccd1 X2_sky130_ef_sc_hd__decap_40_12
XTAP_TAPCELL_ROW_15_388 vccd1 vssd1 X2_sky130_fd_sc_hd__tapvpwrvgnd_1
X_389_ _414_/B _387_/X _389_/B vssd1 vccd1 vccd1 vssd1 X2_sky130_fd_sc_hd__and2b_1
XTAP_TAPCELL_ROW_43_697 vccd1 vssd1 X2_sky130_fd_sc_hd__tapvpwrvgnd_1
XFILLER_56_3 vssd1 vccd1 vssd1 vccd1 X2_sky130_ef_sc_hd__decap_40_12
XFILLER_99_113 vssd1 vccd1 vssd1 vccd1 X2_sky130_ef_sc_hd__decap_40_12
XANTENNA__299__S _299_/S vssd1 vccd1 vccd1 vssd1 X2_sky130_fd_sc_hd__diode_2
XFILLER_95_330 vssd1 vccd1 vccd1 vssd1 X2_sky130_fd_sc_hd__fill_4
XFILLER_68_533 vssd1 vccd1 vssd1 vccd1 X2_sky130_ef_sc_hd__decap_40_12
XFILLER_28_419 vccd1 vssd1 vccd1 vssd1 X2_sky130_fd_sc_hd__fill_1
XFILLER_95_374 vssd1 vccd1 vccd1 vssd1 X2_sky130_fd_sc_hd__fill_2
XFILLER_83_503 vccd1 vssd1 vccd1 vssd1 X2_sky130_fd_sc_hd__fill_1
XFILLER_55_205 vssd1 vccd1 vssd1 vccd1 X2_sky130_ef_sc_hd__decap_40_12
XFILLER_55_249 vssd1 vccd1 vssd1 vccd1 X2_sky130_ef_sc_hd__decap_40_12
XFILLER_36_463 vssd1 vccd1 vssd1 vccd1 X2_sky130_ef_sc_hd__decap_40_12
XFILLER_23_113 vssd1 vccd1 vssd1 vccd1 X2_sky130_ef_sc_hd__decap_40_12
XFILLER_36_496 vssd1 vccd1 vccd1 vssd1 X2_sky130_fd_sc_hd__fill_8
XFILLER_51_488 vssd1 vccd1 vccd1 vssd1 X2_sky130_fd_sc_hd__fill_2
XFILLER_11_57 vssd1 vccd1 vssd1 vccd1 X2_sky130_ef_sc_hd__decap_40_12
XFILLER_3_529 vssd1 vccd1 vssd1 vccd1 X2_sky130_ef_sc_hd__decap_40_12
XFILLER_87_39 vssd1 vccd1 vssd1 vccd1 X2_sky130_ef_sc_hd__decap_40_12
XFILLER_86_363 vccd1 vssd1 vccd1 vssd1 X2_sky130_fd_sc_hd__fill_1
XFILLER_59_599 vccd1 vssd1 vccd1 vssd1 X2_sky130_fd_sc_hd__fill_1
XANTENNA_fanout63_A _527_/A vssd1 vccd1 vccd1 vssd1 X2_sky130_fd_sc_hd__diode_2
XFILLER_100_195 vccd1 vssd1 vccd1 vssd1 X2_sky130_fd_sc_hd__fill_1
XFILLER_74_525 vssd1 vccd1 vccd1 vssd1 X2_sky130_fd_sc_hd__fill_4
XFILLER_27_441 vssd1 vccd1 vccd1 vssd1 X2_sky130_fd_sc_hd__fill_4
XFILLER_27_485 vssd1 vccd1 vssd1 vccd1 X2_sky130_ef_sc_hd__decap_40_12
XFILLER_36_65 vssd1 vccd1 vssd1 vccd1 X2_sky130_ef_sc_hd__decap_40_12
X_312_ vccd1 vssd1 vccd1 vssd1 hold26/X _303_/X _312_/X _304_/X hold25/X _311_/X X2_sky130_fd_sc_hd__a221o_1
XFILLER_42_477 vssd1 vccd1 vssd1 vccd1 X2_sky130_ef_sc_hd__decap_40_12
XFILLER_52_53 vssd1 vccd1 vssd1 vccd1 X2_sky130_ef_sc_hd__decap_40_12
XFILLER_6_301 vssd1 vccd1 vccd1 vssd1 X2_sky130_fd_sc_hd__fill_4
XTAP_TAPCELL_ROW_12_347 vccd1 vssd1 X2_sky130_fd_sc_hd__tapvpwrvgnd_1
XTAP_TAPCELL_ROW_40_656 vccd1 vssd1 X2_sky130_fd_sc_hd__tapvpwrvgnd_1
Xinput18 vssd1 vccd1 _270_/B wbs_adr_i[4] vccd1 vssd1 X2_sky130_fd_sc_hd__buf_1
XFILLER_52_97 vssd1 vccd1 vssd1 vccd1 X2_sky130_ef_sc_hd__decap_40_12
XFILLER_10_363 vccd1 vssd1 vccd1 vssd1 X2_sky130_fd_sc_hd__fill_1
Xinput29 vssd1 vccd1 _274_/A0 wbs_dat_i[15] vccd1 vssd1 X2_sky130_fd_sc_hd__clkbuf_1
XFILLER_6_345 vssd1 vccd1 vssd1 vccd1 X2_sky130_ef_sc_hd__decap_40_12
XFILLER_6_389 vssd1 vccd1 vssd1 vccd1 X2_sky130_ef_sc_hd__decap_40_12
XTAP_TAPCELL_ROW_75_1043 vccd1 vssd1 X2_sky130_fd_sc_hd__tapvpwrvgnd_1
XFILLER_97_617 vssd1 vccd1 vccd1 vssd1 X2_sky130_fd_sc_hd__fill_8
XFILLER_69_319 vccd1 vssd1 vccd1 vssd1 X2_sky130_fd_sc_hd__fill_1
XFILLER_77_385 vssd1 vccd1 vccd1 vssd1 X2_sky130_fd_sc_hd__fill_4
XTAP_TAPCELL_ROW_48_745 vccd1 vssd1 X2_sky130_fd_sc_hd__tapvpwrvgnd_1
XFILLER_65_569 vssd1 vccd1 vccd1 vssd1 X2_sky130_fd_sc_hd__fill_2
XFILLER_33_400 vssd1 vccd1 vssd1 vccd1 X2_sky130_ef_sc_hd__decap_40_12
XFILLER_93_93 vssd1 vccd1 vssd1 vccd1 X2_sky130_ef_sc_hd__decap_40_12
XFILLER_92_377 vssd1 vccd1 vssd1 vccd1 X2_sky130_ef_sc_hd__decap_40_12
XTAP_TAPCELL_ROW_86_1161 vccd1 vssd1 X2_sky130_fd_sc_hd__tapvpwrvgnd_1
XFILLER_33_422 vccd1 vssd1 vccd1 vssd1 X2_sky130_fd_sc_hd__fill_1
XFILLER_21_617 vssd1 vccd1 vccd1 vssd1 X2_sky130_fd_sc_hd__fill_8
XFILLER_60_241 vssd1 vccd1 vccd1 vssd1 X2_sky130_fd_sc_hd__fill_2
XFILLER_9_161 vssd1 vccd1 vccd1 vssd1 X2_sky130_fd_sc_hd__fill_4
XTAP_TAPCELL_ROW_97_1290 vccd1 vssd1 X2_sky130_fd_sc_hd__tapvpwrvgnd_1
XFILLER_87_105 vssd1 vccd1 vccd1 vssd1 X2_sky130_fd_sc_hd__fill_4
XFILLER_87_149 vssd1 vccd1 vssd1 vccd1 X2_sky130_ef_sc_hd__decap_40_12
XFILLER_68_363 vccd1 vssd1 vccd1 vssd1 X2_sky130_fd_sc_hd__fill_1
XFILLER_95_193 vssd1 vccd1 vssd1 vccd1 X2_sky130_ef_sc_hd__decap_40_12
XFILLER_83_333 vssd1 vccd1 vccd1 vssd1 X2_sky130_fd_sc_hd__fill_2
XFILLER_56_525 vssd1 vccd1 vccd1 vssd1 X2_sky130_fd_sc_hd__fill_4
XFILLER_28_249 vssd1 vccd1 vccd1 vssd1 X2_sky130_fd_sc_hd__fill_2
XFILLER_56_569 vssd1 vccd1 vccd1 vssd1 X2_sky130_fd_sc_hd__fill_2
XFILLER_36_271 vssd1 vccd1 vssd1 vccd1 X2_sky130_ef_sc_hd__decap_40_12
XFILLER_71_517 vssd1 vccd1 vssd1 vccd1 X2_sky130_ef_sc_hd__decap_40_12
XFILLER_24_433 vssd1 vccd1 vssd1 vccd1 X2_sky130_ef_sc_hd__decap_40_12
XFILLER_11_105 vssd1 vccd1 vccd1 vssd1 X2_sky130_fd_sc_hd__fill_4
XFILLER_24_477 vssd1 vccd1 vssd1 vccd1 X2_sky130_ef_sc_hd__decap_40_12
XFILLER_7_109 vssd1 vccd1 vccd1 vssd1 X2_sky130_fd_sc_hd__fill_2
XFILLER_11_149 vssd1 vccd1 vssd1 vccd1 X2_sky130_ef_sc_hd__decap_40_12
XFILLER_98_27 vccd1 vssd1 vccd1 vssd1 X2_sky130_fd_sc_hd__fill_1
XFILLER_3_337 vssd1 vccd1 vssd1 vccd1 X2_sky130_ef_sc_hd__decap_40_12
XANTENNA__521__A _521_/A vssd1 vccd1 vccd1 vssd1 X2_sky130_fd_sc_hd__diode_2
XFILLER_79_617 vssd1 vccd1 vccd1 vssd1 X2_sky130_fd_sc_hd__fill_8
XANTENNA__553__CLK _553_/CLK vssd1 vccd1 vccd1 vssd1 X2_sky130_fd_sc_hd__diode_2
XFILLER_19_205 vssd1 vccd1 vssd1 vccd1 X2_sky130_ef_sc_hd__decap_40_12
XFILLER_59_341 vssd1 vccd1 vccd1 vssd1 X2_sky130_fd_sc_hd__fill_2
XFILLER_74_333 vssd1 vccd1 vssd1 vccd1 X2_sky130_ef_sc_hd__decap_40_12
XFILLER_59_385 vssd1 vccd1 vccd1 vssd1 X2_sky130_fd_sc_hd__fill_4
XFILLER_47_525 vssd1 vccd1 vccd1 vssd1 X2_sky130_fd_sc_hd__fill_8
XFILLER_19_249 vssd1 vccd1 vssd1 vccd1 X2_sky130_ef_sc_hd__decap_40_12
XFILLER_86_193 vssd1 vccd1 vccd1 vssd1 X2_sky130_fd_sc_hd__fill_2
XTAP_TAPCELL_ROW_17_406 vccd1 vssd1 X2_sky130_fd_sc_hd__tapvpwrvgnd_1
XFILLER_34_208 vssd1 vccd1 vccd1 vssd1 X2_sky130_fd_sc_hd__fill_2
XFILLER_74_377 vssd1 vccd1 vssd1 vccd1 X2_sky130_ef_sc_hd__decap_40_12
XTAP_TAPCELL_ROW_45_715 vccd1 vssd1 X2_sky130_fd_sc_hd__tapvpwrvgnd_1
XFILLER_27_293 vssd1 vccd1 vssd1 vccd1 X2_sky130_ef_sc_hd__decap_40_12
XTAP_TAPCELL_ROW_25_494 vccd1 vssd1 X2_sky130_fd_sc_hd__tapvpwrvgnd_1
XFILLER_30_469 vssd1 vccd1 vccd1 vssd1 X2_sky130_fd_sc_hd__fill_4
XFILLER_6_153 vssd1 vccd1 vssd1 vccd1 X2_sky130_ef_sc_hd__decap_40_12
XFILLER_10_193 vssd1 vccd1 vccd1 vssd1 X2_sky130_fd_sc_hd__fill_2
XFILLER_6_197 vssd1 vccd1 vssd1 vccd1 X2_sky130_ef_sc_hd__decap_40_12
XFILLER_69_105 vssd1 vccd1 vccd1 vssd1 X2_sky130_fd_sc_hd__fill_4
Xtop_soc_73 wbs_dat_o[21] top_soc_73/HI vccd1 vssd1 vssd1 vccd1 X2_sky130_fd_sc_hd__conb_1
XFILLER_85_609 vssd1 vccd1 vccd1 vssd1 X2_sky130_fd_sc_hd__fill_4
XFILLER_97_436 vssd1 vccd1 vssd1 vccd1 X2_sky130_ef_sc_hd__decap_40_12
XFILLER_69_149 vssd1 vccd1 vssd1 vccd1 X2_sky130_ef_sc_hd__decap_40_12
XFILLER_19_3 vssd1 vccd1 vssd1 vccd1 X2_sky130_ef_sc_hd__decap_40_12
XFILLER_38_514 vssd1 vccd1 vccd1 vssd1 X2_sky130_fd_sc_hd__fill_2
XFILLER_38_569 vssd1 vccd1 vssd1 vccd1 X2_sky130_ef_sc_hd__decap_40_12
XFILLER_92_141 vssd1 vccd1 vssd1 vccd1 X2_sky130_ef_sc_hd__decap_40_12
XFILLER_77_193 vssd1 vccd1 vssd1 vccd1 X2_sky130_ef_sc_hd__decap_40_12
XFILLER_53_517 vssd1 vccd1 vssd1 vccd1 X2_sky130_ef_sc_hd__decap_40_12
XFILLER_61_561 vssd1 vccd1 vccd1 vssd1 X2_sky130_fd_sc_hd__fill_8
XFILLER_33_274 vssd1 vccd1 vccd1 vssd1 X2_sky130_fd_sc_hd__fill_4
XFILLER_21_447 vccd1 vssd1 vccd1 vssd1 X2_sky130_fd_sc_hd__fill_1
XFILLER_0_307 vccd1 vssd1 vccd1 vssd1 X2_sky130_fd_sc_hd__fill_1
XFILLER_29_503 vccd1 vssd1 vccd1 vssd1 X2_sky130_fd_sc_hd__fill_1
XFILLER_88_469 vssd1 vccd1 vccd1 vssd1 X2_sky130_fd_sc_hd__fill_4
XFILLER_84_29 vssd1 vccd1 vssd1 vccd1 X2_sky130_ef_sc_hd__decap_40_12
XFILLER_68_193 vssd1 vccd1 vccd1 vssd1 X2_sky130_fd_sc_hd__fill_2
XFILLER_56_377 vssd1 vccd1 vssd1 vccd1 X2_sky130_ef_sc_hd__decap_40_12
XFILLER_44_539 vssd1 vccd1 vssd1 vccd1 X2_sky130_ef_sc_hd__decap_40_12
XANTENNA__516__A _527_/A vssd1 vccd1 vccd1 vssd1 X2_sky130_fd_sc_hd__diode_2
XFILLER_12_469 vssd1 vccd1 vccd1 vssd1 X2_sky130_fd_sc_hd__fill_4
XFILLER_33_55 vccd1 vssd1 vccd1 vssd1 X2_sky130_fd_sc_hd__fill_1
XTAP_TAPCELL_ROW_22_464 vccd1 vssd1 X2_sky130_fd_sc_hd__tapvpwrvgnd_1
XTAP_TAPCELL_ROW_50_773 vccd1 vssd1 X2_sky130_fd_sc_hd__tapvpwrvgnd_1
XFILLER_4_613 vssd1 vccd1 vssd1 vccd1 X2_sky130_ef_sc_hd__decap_40_12
XPHY_EDGE_ROW_18_Left_120 vccd1 vssd1 vccd1 vssd1 X2_sky130_fd_sc_hd__decap_3
XFILLER_3_167 vccd1 vssd1 vccd1 vssd1 X2_sky130_fd_sc_hd__fill_1
XTAP_TAPCELL_ROW_72_1013 vccd1 vssd1 X2_sky130_fd_sc_hd__tapvpwrvgnd_1
XFILLER_79_447 vccd1 vssd1 vccd1 vssd1 X2_sky130_fd_sc_hd__fill_1
XFILLER_94_417 vssd1 vccd1 vccd1 vssd1 X2_sky130_fd_sc_hd__fill_2
XFILLER_58_41 vssd1 vccd1 vssd1 vccd1 X2_sky130_ef_sc_hd__decap_40_12
Xhold7 hold7/X hold7/A vccd1 vssd1 vssd1 vccd1 X2_sky130_fd_sc_hd__dlygate4sd3_1
XFILLER_58_85 vssd1 vccd1 vssd1 vccd1 X2_sky130_ef_sc_hd__decap_40_12
XFILLER_74_141 vssd1 vccd1 vssd1 vccd1 X2_sky130_ef_sc_hd__decap_40_12
XFILLER_59_193 vssd1 vccd1 vssd1 vccd1 X2_sky130_ef_sc_hd__decap_40_12
XFILLER_47_355 vccd1 vssd1 vccd1 vssd1 X2_sky130_fd_sc_hd__fill_1
XFILLER_47_333 vssd1 vccd1 vccd1 vssd1 X2_sky130_fd_sc_hd__fill_2
XFILLER_35_517 vssd1 vccd1 vssd1 vccd1 X2_sky130_ef_sc_hd__decap_40_12
XFILLER_90_601 vssd1 vccd1 vssd1 vccd1 X2_sky130_ef_sc_hd__decap_40_12
XTAP_TAPCELL_ROW_58_862 vccd1 vssd1 X2_sky130_fd_sc_hd__tapvpwrvgnd_1
XFILLER_47_388 vssd1 vccd1 vccd1 vssd1 X2_sky130_fd_sc_hd__fill_4
XTAP_TAPCELL_ROW_83_1131 vccd1 vssd1 X2_sky130_fd_sc_hd__tapvpwrvgnd_1
XFILLER_43_561 vccd1 vssd1 vccd1 vssd1 X2_sky130_fd_sc_hd__fill_1
XFILLER_43_583 vssd1 vccd1 vccd1 vssd1 X2_sky130_fd_sc_hd__fill_2
XFILLER_30_233 vssd1 vccd1 vssd1 vccd1 X2_sky130_ef_sc_hd__decap_40_12
XFILLER_30_288 vssd1 vccd1 vccd1 vssd1 X2_sky130_fd_sc_hd__fill_2
XFILLER_90_83 vccd1 vssd1 vccd1 vssd1 X2_sky130_fd_sc_hd__fill_1
XANTENNA__599__CLK _599_/CLK vssd1 vccd1 vccd1 vssd1 X2_sky130_fd_sc_hd__diode_2
XFILLER_7_473 vssd1 vccd1 vssd1 vccd1 X2_sky130_ef_sc_hd__decap_40_12
XFILLER_99_81 vssd1 vccd1 vssd1 vccd1 X2_sky130_ef_sc_hd__decap_40_12
XFILLER_97_277 vssd1 vccd1 vccd1 vssd1 X2_sky130_fd_sc_hd__fill_2
XFILLER_85_417 vssd1 vccd1 vssd1 vccd1 X2_sky130_ef_sc_hd__decap_40_12
XFILLER_66_620 vccd1 vssd1 vccd1 vssd1 X2_sky130_fd_sc_hd__fill_1
XFILLER_93_461 vssd1 vccd1 vssd1 vccd1 X2_sky130_ef_sc_hd__decap_40_12
XFILLER_80_133 vssd1 vccd1 vccd1 vssd1 X2_sky130_fd_sc_hd__fill_4
XFILLER_53_347 vssd1 vccd1 vccd1 vssd1 X2_sky130_fd_sc_hd__fill_2
XFILLER_0_81 vssd1 vccd1 vccd1 vssd1 X2_sky130_fd_sc_hd__fill_2
XFILLER_80_177 vssd1 vccd1 vssd1 vccd1 X2_sky130_ef_sc_hd__decap_40_12
XFILLER_21_277 vssd1 vccd1 vccd1 vssd1 X2_sky130_fd_sc_hd__fill_2
XFILLER_88_233 vssd1 vccd1 vssd1 vccd1 X2_sky130_ef_sc_hd__decap_40_12
XFILLER_95_39 vssd1 vccd1 vssd1 vccd1 X2_sky130_ef_sc_hd__decap_40_12
XFILLER_76_417 vssd1 vccd1 vccd1 vssd1 X2_sky130_fd_sc_hd__fill_2
XFILLER_88_277 vssd1 vccd1 vssd1 vccd1 X2_sky130_ef_sc_hd__decap_40_12
XFILLER_17_517 vssd1 vccd1 vssd1 vccd1 X2_sky130_ef_sc_hd__decap_40_12
XFILLER_28_77 vssd1 vccd1 vccd1 vssd1 X2_sky130_fd_sc_hd__fill_4
X_560_ vssd1 vccd1 vccd1 vssd1 _608_/CLK _560_/D _480_/Y _560_/Q X2_sky130_fd_sc_hd__dfrtp_1
XFILLER_56_141 vssd1 vccd1 vssd1 vccd1 X2_sky130_ef_sc_hd__decap_40_12
XTAP_TAPCELL_ROW_27_512 vccd1 vssd1 X2_sky130_fd_sc_hd__tapvpwrvgnd_1
XFILLER_71_111 vccd1 vssd1 vccd1 vssd1 X2_sky130_fd_sc_hd__fill_1
XTAP_TAPCELL_ROW_55_821 vccd1 vssd1 X2_sky130_fd_sc_hd__tapvpwrvgnd_1
XFILLER_25_561 vssd1 vccd1 vssd1 vccd1 X2_sky130_ef_sc_hd__decap_40_12
X_491_ vccd1 vssd1 vccd1 vssd1 _491_/Y _525_/A X2_sky130_fd_sc_hd__inv_2
XFILLER_52_380 vssd1 vccd1 vccd1 vssd1 X2_sky130_fd_sc_hd__fill_2
XFILLER_44_65 vssd1 vccd1 vssd1 vccd1 X2_sky130_ef_sc_hd__decap_40_12
XFILLER_12_233 vssd1 vccd1 vssd1 vccd1 X2_sky130_ef_sc_hd__decap_40_12
XFILLER_40_531 vccd1 vssd1 vccd1 vssd1 X2_sky130_fd_sc_hd__fill_1
XFILLER_12_277 vssd1 vccd1 vssd1 vccd1 X2_sky130_ef_sc_hd__decap_40_12
XFILLER_40_586 vssd1 vccd1 vccd1 vssd1 X2_sky130_fd_sc_hd__fill_2
XFILLER_60_53 vssd1 vccd1 vssd1 vccd1 X2_sky130_ef_sc_hd__decap_40_12
XFILLER_60_97 vssd1 vccd1 vssd1 vccd1 X2_sky130_ef_sc_hd__decap_40_12
XFILLER_4_421 vssd1 vccd1 vssd1 vccd1 X2_sky130_ef_sc_hd__decap_40_12
XFILLER_5_15 vssd1 vccd1 vssd1 vccd1 X2_sky130_ef_sc_hd__decap_40_12
XFILLER_69_51 vssd1 vccd1 vccd1 vssd1 X2_sky130_fd_sc_hd__fill_4
XTAP_TAPCELL_ROW_7_292 vccd1 vssd1 X2_sky130_fd_sc_hd__tapvpwrvgnd_1
XFILLER_79_277 vssd1 vccd1 vccd1 vssd1 X2_sky130_fd_sc_hd__fill_2
XFILLER_67_417 vssd1 vccd1 vssd1 vccd1 X2_sky130_ef_sc_hd__decap_40_12
XPHY_EDGE_ROW_13_Right_13 vccd1 vssd1 vccd1 vssd1 X2_sky130_fd_sc_hd__decap_3
XFILLER_75_461 vssd1 vccd1 vssd1 vccd1 X2_sky130_ef_sc_hd__decap_40_12
XFILLER_62_133 vssd1 vccd1 vccd1 vssd1 X2_sky130_fd_sc_hd__fill_4
XFILLER_90_475 vccd1 vssd1 vccd1 vssd1 X2_sky130_fd_sc_hd__fill_1
XFILLER_50_306 vssd1 vccd1 vccd1 vssd1 X2_sky130_fd_sc_hd__fill_2
XFILLER_62_177 vssd1 vccd1 vssd1 vccd1 X2_sky130_ef_sc_hd__decap_40_12
XFILLER_50_317 vssd1 vccd1 vccd1 vssd1 X2_sky130_fd_sc_hd__fill_2
XFILLER_31_553 vssd1 vccd1 vccd1 vssd1 X2_sky130_fd_sc_hd__fill_4
XFILLER_86_3 vssd1 vccd1 vssd1 vccd1 X2_sky130_ef_sc_hd__decap_40_12
XPHY_EDGE_ROW_22_Right_22 vccd1 vssd1 vccd1 vssd1 X2_sky130_fd_sc_hd__decap_3
XFILLER_7_281 vssd1 vccd1 vssd1 vccd1 X2_sky130_ef_sc_hd__decap_40_12
XFILLER_98_531 vccd1 vssd1 vccd1 vssd1 X2_sky130_fd_sc_hd__fill_1
XPHY_EDGE_ROW_31_Right_31 vccd1 vssd1 vccd1 vssd1 X2_sky130_fd_sc_hd__decap_3
XFILLER_100_525 vssd1 vccd1 vccd1 vssd1 X2_sky130_fd_sc_hd__fill_4
XFILLER_85_225 vssd1 vccd1 vssd1 vccd1 X2_sky130_ef_sc_hd__decap_40_12
XFILLER_58_417 vssd1 vccd1 vccd1 vssd1 X2_sky130_fd_sc_hd__fill_2
XFILLER_100_569 vssd1 vccd1 vssd1 vccd1 X2_sky130_ef_sc_hd__decap_40_12
XTAP_TAPCELL_ROW_69_979 vccd1 vssd1 X2_sky130_fd_sc_hd__tapvpwrvgnd_1
XFILLER_38_141 vssd1 vccd1 vssd1 vccd1 X2_sky130_ef_sc_hd__decap_40_12
XFILLER_54_601 vssd1 vccd1 vssd1 vccd1 X2_sky130_ef_sc_hd__decap_40_12
XFILLER_53_111 vccd1 vssd1 vccd1 vssd1 X2_sky130_fd_sc_hd__fill_1
XFILLER_81_497 vssd1 vccd1 vccd1 vssd1 X2_sky130_fd_sc_hd__fill_4
XFILLER_22_531 vccd1 vssd1 vccd1 vssd1 X2_sky130_fd_sc_hd__fill_1
XTAP_TAPCELL_ROW_101_1337 vccd1 vssd1 X2_sky130_fd_sc_hd__tapvpwrvgnd_1
XTAP_TAPCELL_ROW_101_1326 vccd1 vssd1 X2_sky130_fd_sc_hd__tapvpwrvgnd_1
XPHY_EDGE_ROW_40_Right_40 vccd1 vssd1 vccd1 vssd1 X2_sky130_fd_sc_hd__decap_3
XTAP_TAPCELL_ROW_32_570 vccd1 vssd1 X2_sky130_fd_sc_hd__tapvpwrvgnd_1
XFILLER_89_553 vssd1 vccd1 vccd1 vssd1 X2_sky130_fd_sc_hd__fill_4
XFILLER_89_597 vssd1 vccd1 vssd1 vccd1 X2_sky130_ef_sc_hd__decap_40_12
XTAP_TAPCELL_ROW_4_262 vccd1 vssd1 X2_sky130_fd_sc_hd__tapvpwrvgnd_1
XFILLER_91_217 vssd1 vccd1 vccd1 vssd1 X2_sky130_fd_sc_hd__fill_4
XFILLER_57_461 vssd1 vccd1 vssd1 vccd1 X2_sky130_ef_sc_hd__decap_40_12
X_543_ vssd1 vccd1 vccd1 vssd1 _609_/CLK _543_/D _463_/Y _543_/Q X2_sky130_fd_sc_hd__dfrtp_1
XFILLER_44_133 vssd1 vccd1 vccd1 vssd1 X2_sky130_fd_sc_hd__fill_4
XTAP_TAPCELL_ROW_80_1101 vccd1 vssd1 X2_sky130_fd_sc_hd__tapvpwrvgnd_1
XFILLER_72_475 vccd1 vssd1 vccd1 vssd1 X2_sky130_fd_sc_hd__fill_1
X_474_ vccd1 vssd1 vccd1 vssd1 _474_/Y _521_/A X2_sky130_fd_sc_hd__inv_2
XFILLER_44_199 vccd1 vssd1 vccd1 vssd1 X2_sky130_fd_sc_hd__fill_1
XFILLER_44_177 vssd1 vccd1 vssd1 vccd1 X2_sky130_ef_sc_hd__decap_40_12
XFILLER_13_553 vssd1 vccd1 vccd1 vssd1 X2_sky130_fd_sc_hd__fill_4
XFILLER_25_391 vccd1 vssd1 vccd1 vssd1 X2_sky130_fd_sc_hd__fill_1
XFILLER_9_557 vssd1 vccd1 vccd1 vssd1 X2_sky130_fd_sc_hd__fill_2
XFILLER_13_597 vssd1 vccd1 vssd1 vccd1 X2_sky130_ef_sc_hd__decap_40_12
XFILLER_4_251 vccd1 vssd1 vccd1 vssd1 X2_sky130_fd_sc_hd__fill_1
XTAP_TAPCELL_ROW_78_1074 vccd1 vssd1 X2_sky130_fd_sc_hd__tapvpwrvgnd_1
XANTENNA__296__A0 _446_/A1 vssd1 vccd1 vccd1 vssd1 X2_sky130_fd_sc_hd__diode_2
XFILLER_95_501 vssd1 vccd1 vccd1 vssd1 X2_sky130_fd_sc_hd__fill_2
XFILLER_67_225 vssd1 vccd1 vssd1 vccd1 X2_sky130_ef_sc_hd__decap_40_12
XFILLER_35_111 vccd1 vssd1 vccd1 vssd1 X2_sky130_fd_sc_hd__fill_1
XTAP_TAPCELL_ROW_66_949 vccd1 vssd1 X2_sky130_fd_sc_hd__tapvpwrvgnd_1
XFILLER_23_317 vssd1 vccd1 vssd1 vccd1 X2_sky130_ef_sc_hd__decap_40_12
XFILLER_51_615 vccd1 vssd1 vccd1 vssd1 X2_sky130_fd_sc_hd__fill_1
XFILLER_31_350 vssd1 vccd1 vssd1 vccd1 X2_sky130_ef_sc_hd__decap_40_12
XANTENNA__317__C _317_/C vssd1 vccd1 vccd1 vssd1 X2_sky130_fd_sc_hd__diode_2
XANTENNA__287__A0 _297_/A0 vssd1 vccd1 vccd1 vssd1 X2_sky130_fd_sc_hd__diode_2
XFILLER_98_361 vssd1 vccd1 vccd1 vssd1 X2_sky130_fd_sc_hd__fill_2
XFILLER_100_300 vssd1 vccd1 vccd1 vssd1 X2_sky130_fd_sc_hd__fill_8
XFILLER_86_501 vssd1 vccd1 vssd1 vccd1 X2_sky130_ef_sc_hd__decap_40_12
XFILLER_86_545 vssd1 vccd1 vssd1 vccd1 X2_sky130_ef_sc_hd__decap_40_12
XFILLER_39_461 vssd1 vccd1 vssd1 vccd1 X2_sky130_ef_sc_hd__decap_40_12
XFILLER_86_589 vssd1 vccd1 vssd1 vccd1 X2_sky130_ef_sc_hd__decap_40_12
XFILLER_73_217 vssd1 vccd1 vccd1 vssd1 X2_sky130_fd_sc_hd__fill_4
XTAP_TAPCELL_ROW_1_232 vccd1 vssd1 X2_sky130_fd_sc_hd__tapvpwrvgnd_1
XFILLER_66_280 vssd1 vccd1 vccd1 vssd1 X2_sky130_fd_sc_hd__fill_2
XFILLER_26_133 vssd1 vccd1 vccd1 vssd1 X2_sky130_fd_sc_hd__fill_4
XFILLER_92_29 vssd1 vccd1 vssd1 vccd1 X2_sky130_ef_sc_hd__decap_40_12
XFILLER_54_464 vssd1 vccd1 vccd1 vssd1 X2_sky130_fd_sc_hd__fill_2
XFILLER_54_431 vccd1 vssd1 vccd1 vssd1 X2_sky130_fd_sc_hd__fill_1
XFILLER_26_177 vssd1 vccd1 vssd1 vccd1 X2_sky130_ef_sc_hd__decap_40_12
XFILLER_81_261 vssd1 vccd1 vssd1 vccd1 X2_sky130_ef_sc_hd__decap_40_12
XFILLER_54_486 vssd1 vccd1 vssd1 vccd1 X2_sky130_ef_sc_hd__decap_40_12
XFILLER_41_125 vssd1 vccd1 vssd1 vccd1 X2_sky130_ef_sc_hd__decap_40_12
XFILLER_10_501 vssd1 vccd1 vssd1 vccd1 X2_sky130_ef_sc_hd__decap_40_12
XFILLER_22_361 vssd1 vccd1 vccd1 vssd1 X2_sky130_fd_sc_hd__fill_2
XFILLER_41_169 vssd1 vccd1 vccd1 vssd1 X2_sky130_fd_sc_hd__fill_4
XFILLER_10_545 vssd1 vccd1 vssd1 vccd1 X2_sky130_ef_sc_hd__decap_40_12
XFILLER_41_55 vccd1 vssd1 vccd1 vssd1 X2_sky130_fd_sc_hd__fill_1
XANTENNA__524__A _525_/A vssd1 vccd1 vccd1 vssd1 X2_sky130_fd_sc_hd__diode_2
XFILLER_10_589 vssd1 vccd1 vssd1 vccd1 X2_sky130_ef_sc_hd__decap_40_12
XTAP_TAPCELL_ROW_9_321 vccd1 vssd1 X2_sky130_fd_sc_hd__tapvpwrvgnd_1
XFILLER_1_221 vssd1 vccd1 vccd1 vssd1 X2_sky130_fd_sc_hd__fill_2
XFILLER_96_309 vccd1 vssd1 vccd1 vssd1 X2_sky130_fd_sc_hd__fill_1
XFILLER_1_265 vssd1 vccd1 vccd1 vssd1 X2_sky130_fd_sc_hd__fill_2
XFILLER_1_276 vssd1 vccd1 vccd1 vssd1 X2_sky130_fd_sc_hd__fill_4
XFILLER_89_361 vssd1 vccd1 vssd1 vccd1 X2_sky130_ef_sc_hd__decap_40_12
XFILLER_77_501 vssd1 vccd1 vccd1 vssd1 X2_sky130_fd_sc_hd__fill_2
XFILLER_2_27 vccd1 vssd1 vccd1 vssd1 X2_sky130_fd_sc_hd__fill_1
XFILLER_49_225 vssd1 vccd1 vssd1 vccd1 X2_sky130_ef_sc_hd__decap_40_12
XFILLER_18_601 vssd1 vccd1 vssd1 vccd1 X2_sky130_ef_sc_hd__decap_40_12
XFILLER_66_41 vssd1 vccd1 vssd1 vccd1 X2_sky130_ef_sc_hd__decap_40_12
XFILLER_17_111 vccd1 vssd1 vccd1 vssd1 X2_sky130_fd_sc_hd__fill_1
XFILLER_66_85 vssd1 vccd1 vssd1 vccd1 X2_sky130_ef_sc_hd__decap_40_12
XTAP_TAPCELL_ROW_63_908 vccd1 vssd1 X2_sky130_fd_sc_hd__tapvpwrvgnd_1
X_526_ vccd1 vssd1 vccd1 vssd1 _526_/Y _527_/A X2_sky130_fd_sc_hd__inv_2
XFILLER_60_401 vssd1 vccd1 vssd1 vccd1 X2_sky130_ef_sc_hd__decap_40_12
XFILLER_60_445 vssd1 vccd1 vssd1 vccd1 X2_sky130_ef_sc_hd__decap_40_12
XFILLER_13_361 vssd1 vccd1 vssd1 vccd1 X2_sky130_ef_sc_hd__decap_40_12
XFILLER_20_309 vssd1 vccd1 vssd1 vccd1 X2_sky130_ef_sc_hd__decap_40_12
XFILLER_60_489 vssd1 vccd1 vssd1 vccd1 X2_sky130_ef_sc_hd__decap_40_12
X_457_ vccd1 vssd1 vccd1 vssd1 _457_/Y _473_/A X2_sky130_fd_sc_hd__inv_2
XTAP_TAPCELL_ROW_15_389 vccd1 vssd1 X2_sky130_fd_sc_hd__tapvpwrvgnd_1
XTAP_TAPCELL_ROW_71_996 vccd1 vssd1 X2_sky130_fd_sc_hd__tapvpwrvgnd_1
X_388_ vccd1 vssd1 vssd1 vccd1 _552_/Q _537_/Q _389_/B X2_sky130_fd_sc_hd__nand2b_1
XTAP_TAPCELL_ROW_43_698 vccd1 vssd1 X2_sky130_fd_sc_hd__tapvpwrvgnd_1
XFILLER_99_125 vssd1 vccd1 vssd1 vccd1 X2_sky130_ef_sc_hd__decap_40_12
XFILLER_99_169 vssd1 vccd1 vssd1 vccd1 X2_sky130_ef_sc_hd__decap_40_12
XFILLER_49_3 vssd1 vccd1 vssd1 vccd1 X2_sky130_ef_sc_hd__decap_40_12
XFILLER_68_501 vssd1 vccd1 vssd1 vccd1 X2_sky130_ef_sc_hd__decap_40_12
XFILLER_68_545 vssd1 vccd1 vssd1 vccd1 X2_sky130_ef_sc_hd__decap_40_12
XFILLER_68_589 vccd1 vssd1 vccd1 vssd1 X2_sky130_fd_sc_hd__fill_1
XFILLER_68_578 vssd1 vccd1 vccd1 vssd1 X2_sky130_fd_sc_hd__fill_2
XFILLER_55_217 vssd1 vccd1 vccd1 vssd1 X2_sky130_fd_sc_hd__fill_4
XFILLER_83_559 vccd1 vssd1 vccd1 vssd1 X2_sky130_fd_sc_hd__fill_1
XFILLER_70_209 vssd1 vccd1 vssd1 vccd1 X2_sky130_ef_sc_hd__decap_40_12
XFILLER_36_475 vccd1 vssd1 vccd1 vssd1 X2_sky130_fd_sc_hd__fill_1
XFILLER_63_261 vssd1 vccd1 vssd1 vccd1 X2_sky130_ef_sc_hd__decap_40_12
XFILLER_23_125 vssd1 vccd1 vssd1 vccd1 X2_sky130_ef_sc_hd__decap_40_12
XFILLER_23_169 vssd1 vccd1 vssd1 vccd1 X2_sky130_ef_sc_hd__decap_40_12
XFILLER_11_69 vssd1 vccd1 vssd1 vccd1 X2_sky130_ef_sc_hd__decap_40_12
XFILLER_78_309 vssd1 vccd1 vssd1 vccd1 X2_sky130_ef_sc_hd__decap_40_12
XFILLER_59_501 vssd1 vccd1 vccd1 vssd1 X2_sky130_fd_sc_hd__fill_2
XFILLER_100_141 vssd1 vccd1 vssd1 vccd1 X2_sky130_ef_sc_hd__decap_40_12
XFILLER_46_206 vccd1 vssd1 vccd1 vssd1 X2_sky130_fd_sc_hd__fill_1
XANTENNA__519__A _521_/A vssd1 vccd1 vccd1 vssd1 X2_sky130_fd_sc_hd__diode_2
XFILLER_15_615 vccd1 vssd1 vccd1 vssd1 X2_sky130_fd_sc_hd__fill_1
XFILLER_36_77 vssd1 vccd1 vccd1 vssd1 X2_sky130_fd_sc_hd__fill_4
XFILLER_82_581 vssd1 vccd1 vccd1 vssd1 X2_sky130_fd_sc_hd__fill_4
XFILLER_54_261 vssd1 vccd1 vccd1 vssd1 X2_sky130_fd_sc_hd__fill_2
XFILLER_27_497 vssd1 vccd1 vccd1 vssd1 X2_sky130_fd_sc_hd__fill_4
XFILLER_30_618 vssd1 vccd1 vccd1 vssd1 X2_sky130_fd_sc_hd__fill_2
X_311_ vssd1 vccd1 _311_/X _317_/B _541_/Q _317_/C vccd1 vssd1 X2_sky130_fd_sc_hd__and3_1
XFILLER_42_489 vssd1 vccd1 vccd1 vssd1 X2_sky130_fd_sc_hd__fill_4
XANTENNA_clkbuf_3_3__f_wb_clk_i_A clkbuf_0_wb_clk_i/X vssd1 vccd1 vccd1 vssd1 X2_sky130_fd_sc_hd__diode_2
XFILLER_52_65 vssd1 vccd1 vssd1 vccd1 X2_sky130_ef_sc_hd__decap_40_12
XTAP_TAPCELL_ROW_12_348 vccd1 vssd1 X2_sky130_fd_sc_hd__tapvpwrvgnd_1
XTAP_TAPCELL_ROW_40_657 vccd1 vssd1 X2_sky130_fd_sc_hd__tapvpwrvgnd_1
Xinput19 vssd1 vccd1 _309_/A wbs_adr_i[5] vccd1 vssd1 X2_sky130_fd_sc_hd__buf_1
XFILLER_6_357 vssd1 vccd1 vccd1 vssd1 X2_sky130_fd_sc_hd__fill_4
XTAP_TAPCELL_ROW_75_1044 vccd1 vssd1 X2_sky130_fd_sc_hd__tapvpwrvgnd_1
XFILLER_2_585 vssd1 vccd1 vccd1 vssd1 X2_sky130_fd_sc_hd__fill_2
XFILLER_96_139 vccd1 vssd1 vccd1 vssd1 X2_sky130_fd_sc_hd__fill_1
XFILLER_77_51 vssd1 vccd1 vccd1 vssd1 X2_sky130_fd_sc_hd__fill_4
XFILLER_37_217 vccd1 vssd1 vccd1 vssd1 X2_sky130_fd_sc_hd__fill_1
XFILLER_37_228 vssd1 vccd1 vssd1 vccd1 X2_sky130_ef_sc_hd__decap_40_12
XFILLER_65_559 vccd1 vssd1 vccd1 vssd1 X2_sky130_fd_sc_hd__fill_1
XTAP_TAPCELL_ROW_48_746 vccd1 vssd1 X2_sky130_fd_sc_hd__tapvpwrvgnd_1
XFILLER_18_475 vccd1 vssd1 vccd1 vssd1 X2_sky130_fd_sc_hd__fill_1
XFILLER_33_412 vssd1 vccd1 vccd1 vssd1 X2_sky130_fd_sc_hd__fill_8
XFILLER_92_389 vssd1 vccd1 vssd1 vccd1 X2_sky130_ef_sc_hd__decap_40_12
XTAP_TAPCELL_ROW_86_1162 vccd1 vssd1 X2_sky130_fd_sc_hd__tapvpwrvgnd_1
XFILLER_80_529 vssd1 vccd1 vccd1 vssd1 X2_sky130_fd_sc_hd__fill_2
XFILLER_45_261 vssd1 vccd1 vssd1 vccd1 X2_sky130_ef_sc_hd__decap_40_12
XFILLER_73_592 vssd1 vccd1 vccd1 vssd1 X2_sky130_fd_sc_hd__fill_4
XFILLER_60_253 vccd1 vssd1 vccd1 vssd1 X2_sky130_fd_sc_hd__fill_1
X_509_ vccd1 vssd1 vccd1 vssd1 _509_/Y _517_/A X2_sky130_fd_sc_hd__inv_2
XFILLER_20_139 vccd1 vssd1 vccd1 vssd1 X2_sky130_fd_sc_hd__fill_1
XTAP_TAPCELL_ROW_97_1291 vccd1 vssd1 X2_sky130_fd_sc_hd__tapvpwrvgnd_1
XFILLER_68_331 vssd1 vccd1 vssd1 vccd1 X2_sky130_ef_sc_hd__decap_40_12
XFILLER_3_81 vssd1 vccd1 vssd1 vccd1 X2_sky130_ef_sc_hd__decap_40_12
XFILLER_95_161 vssd1 vccd1 vccd1 vssd1 X2_sky130_fd_sc_hd__fill_4
XFILLER_24_401 vssd1 vccd1 vssd1 vccd1 X2_sky130_ef_sc_hd__decap_40_12
XFILLER_83_389 vssd1 vccd1 vccd1 vssd1 X2_sky130_fd_sc_hd__fill_2
XFILLER_71_529 vssd1 vccd1 vssd1 vccd1 X2_sky130_ef_sc_hd__decap_40_12
XFILLER_24_445 vssd1 vccd1 vssd1 vccd1 X2_sky130_ef_sc_hd__decap_40_12
XFILLER_36_283 vssd1 vccd1 vssd1 vccd1 X2_sky130_ef_sc_hd__decap_40_12
XFILLER_64_592 vssd1 vccd1 vccd1 vssd1 X2_sky130_fd_sc_hd__fill_4
XFILLER_24_489 vssd1 vccd1 vssd1 vccd1 X2_sky130_ef_sc_hd__decap_40_12
XFILLER_3_305 vssd1 vccd1 vssd1 vccd1 X2_sky130_ef_sc_hd__decap_40_12
XFILLER_3_349 vssd1 vccd1 vssd1 vccd1 X2_sky130_ef_sc_hd__decap_40_12
XFILLER_78_139 vccd1 vssd1 vccd1 vssd1 X2_sky130_fd_sc_hd__fill_1
XFILLER_93_109 vssd1 vccd1 vccd1 vssd1 X2_sky130_fd_sc_hd__fill_2
XFILLER_19_217 vssd1 vccd1 vccd1 vssd1 X2_sky130_fd_sc_hd__fill_4
XFILLER_101_461 vssd1 vccd1 vssd1 vccd1 X2_sky130_ef_sc_hd__decap_40_12
XFILLER_74_301 vssd1 vccd1 vccd1 vssd1 X2_sky130_fd_sc_hd__fill_4
XFILLER_47_515 vssd1 vccd1 vccd1 vssd1 X2_sky130_fd_sc_hd__fill_2
XFILLER_74_345 vssd1 vccd1 vssd1 vccd1 X2_sky130_ef_sc_hd__decap_40_12
XFILLER_47_559 vccd1 vssd1 vccd1 vssd1 X2_sky130_fd_sc_hd__fill_1
XTAP_TAPCELL_ROW_17_407 vccd1 vssd1 X2_sky130_fd_sc_hd__tapvpwrvgnd_1
XFILLER_27_261 vssd1 vccd1 vssd1 vccd1 X2_sky130_ef_sc_hd__decap_40_12
XFILLER_74_389 vssd1 vccd1 vssd1 vccd1 X2_sky130_ef_sc_hd__decap_40_12
XFILLER_62_529 vssd1 vccd1 vccd1 vssd1 X2_sky130_fd_sc_hd__fill_2
XTAP_TAPCELL_ROW_45_716 vccd1 vssd1 X2_sky130_fd_sc_hd__tapvpwrvgnd_1
XFILLER_15_445 vssd1 vccd1 vccd1 vssd1 X2_sky130_fd_sc_hd__fill_2
XPHY_EDGE_ROW_69_Right_69 vccd1 vssd1 vccd1 vssd1 X2_sky130_fd_sc_hd__decap_3
XFILLER_42_253 vssd1 vccd1 vssd1 vccd1 X2_sky130_ef_sc_hd__decap_40_12
XFILLER_8_15 vssd1 vccd1 vssd1 vccd1 X2_sky130_ef_sc_hd__decap_40_12
XTAP_TAPCELL_ROW_25_495 vccd1 vssd1 X2_sky130_fd_sc_hd__tapvpwrvgnd_1
XFILLER_6_121 vssd1 vccd1 vssd1 vccd1 X2_sky130_ef_sc_hd__decap_40_12
XFILLER_6_165 vssd1 vccd1 vssd1 vccd1 X2_sky130_ef_sc_hd__decap_40_12
XANTENNA__271__X _304_/A vssd1 vccd1 vccd1 vssd1 X2_sky130_fd_sc_hd__diode_2
XPHY_EDGE_ROW_78_Right_78 vccd1 vssd1 vccd1 vssd1 X2_sky130_fd_sc_hd__decap_3
Xtop_soc_74 wbs_dat_o[22] top_soc_74/HI vccd1 vssd1 vssd1 vccd1 X2_sky130_fd_sc_hd__conb_1
XFILLER_88_83 vccd1 vssd1 vccd1 vssd1 X2_sky130_fd_sc_hd__fill_1
XFILLER_84_109 vssd1 vccd1 vssd1 vccd1 X2_sky130_ef_sc_hd__decap_40_12
XFILLER_77_161 vssd1 vccd1 vccd1 vssd1 X2_sky130_fd_sc_hd__fill_4
XFILLER_92_153 vssd1 vccd1 vssd1 vccd1 X2_sky130_ef_sc_hd__decap_40_12
XFILLER_53_529 vssd1 vccd1 vssd1 vccd1 X2_sky130_ef_sc_hd__decap_40_12
XPHY_EDGE_ROW_87_Right_87 vccd1 vssd1 vccd1 vssd1 X2_sky130_fd_sc_hd__decap_3
XFILLER_92_197 vssd1 vccd1 vssd1 vccd1 X2_sky130_ef_sc_hd__decap_40_12
XFILLER_33_242 vccd1 vssd1 vccd1 vssd1 X2_sky130_fd_sc_hd__fill_1
XPHY_EDGE_ROW_96_Right_96 vccd1 vssd1 vccd1 vssd1 X2_sky130_fd_sc_hd__decap_3
XANTENNA_clkbuf_3_2__f_wb_clk_i_X _601_/CLK vssd1 vccd1 vccd1 vssd1 X2_sky130_fd_sc_hd__diode_2
XFILLER_88_404 vssd1 vccd1 vssd1 vccd1 X2_sky130_ef_sc_hd__decap_40_12
XFILLER_75_109 vssd1 vccd1 vccd1 vssd1 X2_sky130_fd_sc_hd__fill_2
XFILLER_29_559 vccd1 vssd1 vccd1 vssd1 X2_sky130_fd_sc_hd__fill_1
XFILLER_56_334 vccd1 vssd1 vccd1 vssd1 X2_sky130_fd_sc_hd__fill_1
XFILLER_16_209 vssd1 vccd1 vssd1 vccd1 X2_sky130_ef_sc_hd__decap_40_12
XFILLER_37_570 vssd1 vccd1 vccd1 vssd1 X2_sky130_fd_sc_hd__fill_2
XFILLER_56_389 vssd1 vccd1 vssd1 vccd1 X2_sky130_ef_sc_hd__decap_40_12
XFILLER_17_57 vssd1 vccd1 vssd1 vccd1 X2_sky130_ef_sc_hd__decap_40_12
XFILLER_71_337 vssd1 vccd1 vssd1 vccd1 X2_sky130_ef_sc_hd__decap_40_12
XFILLER_24_253 vssd1 vccd1 vssd1 vccd1 X2_sky130_ef_sc_hd__decap_40_12
XFILLER_8_419 vccd1 vssd1 vccd1 vssd1 X2_sky130_fd_sc_hd__fill_1
XTAP_TAPCELL_ROW_22_465 vccd1 vssd1 X2_sky130_fd_sc_hd__tapvpwrvgnd_1
XTAP_TAPCELL_ROW_50_774 vccd1 vssd1 X2_sky130_fd_sc_hd__tapvpwrvgnd_1
XFILLER_3_113 vssd1 vccd1 vssd1 vccd1 X2_sky130_ef_sc_hd__decap_40_12
XTAP_TAPCELL_ROW_72_1014 vccd1 vssd1 X2_sky130_fd_sc_hd__tapvpwrvgnd_1
XFILLER_66_109 vssd1 vccd1 vssd1 vccd1 X2_sky130_ef_sc_hd__decap_40_12
XFILLER_58_53 vssd1 vccd1 vssd1 vccd1 X2_sky130_ef_sc_hd__decap_40_12
Xhold8 hold8/X hold8/A vccd1 vssd1 vssd1 vccd1 X2_sky130_fd_sc_hd__dlygate4sd3_1
XFILLER_59_161 vssd1 vccd1 vccd1 vssd1 X2_sky130_fd_sc_hd__fill_4
XFILLER_58_97 vssd1 vccd1 vssd1 vccd1 X2_sky130_ef_sc_hd__decap_40_12
XANTENNA_input36_A wbs_dat_i[7] vssd1 vccd1 vccd1 vssd1 X2_sky130_fd_sc_hd__diode_2
XFILLER_35_529 vssd1 vccd1 vssd1 vccd1 X2_sky130_ef_sc_hd__decap_40_12
XFILLER_90_613 vssd1 vccd1 vssd1 vccd1 X2_sky130_ef_sc_hd__decap_40_12
XFILLER_74_153 vssd1 vccd1 vssd1 vccd1 X2_sky130_ef_sc_hd__decap_40_12
XFILLER_74_41 vssd1 vccd1 vssd1 vccd1 X2_sky130_ef_sc_hd__decap_40_12
XTAP_TAPCELL_ROW_58_863 vccd1 vssd1 X2_sky130_fd_sc_hd__tapvpwrvgnd_1
XFILLER_28_581 vssd1 vccd1 vccd1 vssd1 X2_sky130_fd_sc_hd__fill_4
XFILLER_74_197 vssd1 vccd1 vssd1 vccd1 X2_sky130_ef_sc_hd__decap_40_12
XFILLER_74_85 vssd1 vccd1 vssd1 vccd1 X2_sky130_ef_sc_hd__decap_40_12
XTAP_TAPCELL_ROW_83_1132 vccd1 vssd1 X2_sky130_fd_sc_hd__tapvpwrvgnd_1
XFILLER_43_551 vssd1 vccd1 vccd1 vssd1 X2_sky130_fd_sc_hd__fill_8
XFILLER_43_573 vssd1 vccd1 vccd1 vssd1 X2_sky130_fd_sc_hd__fill_2
XFILLER_30_245 vssd1 vccd1 vccd1 vssd1 X2_sky130_fd_sc_hd__fill_4
XFILLER_7_441 vssd1 vccd1 vccd1 vssd1 X2_sky130_fd_sc_hd__fill_4
XFILLER_7_485 vssd1 vccd1 vssd1 vccd1 X2_sky130_ef_sc_hd__decap_40_12
XTAP_TAPCELL_ROW_94_1250 vccd1 vssd1 X2_sky130_fd_sc_hd__tapvpwrvgnd_1
XFILLER_99_93 vssd1 vccd1 vssd1 vccd1 X2_sky130_ef_sc_hd__decap_40_12
XFILLER_31_3 vssd1 vccd1 vssd1 vccd1 X2_sky130_ef_sc_hd__decap_40_12
XFILLER_97_223 vccd1 vssd1 vccd1 vssd1 X2_sky130_fd_sc_hd__fill_1
XFILLER_85_429 vssd1 vccd1 vssd1 vccd1 X2_sky130_ef_sc_hd__decap_40_12
XFILLER_57_109 vssd1 vccd1 vccd1 vssd1 X2_sky130_fd_sc_hd__fill_2
XFILLER_26_529 vssd1 vccd1 vccd1 vssd1 X2_sky130_fd_sc_hd__fill_2
XFILLER_93_473 vssd1 vccd1 vssd1 vccd1 X2_sky130_ef_sc_hd__decap_40_12
XFILLER_81_613 vssd1 vccd1 vccd1 vssd1 X2_sky130_fd_sc_hd__fill_2
XFILLER_53_337 vssd1 vccd1 vccd1 vssd1 X2_sky130_fd_sc_hd__fill_4
XFILLER_80_189 vssd1 vccd1 vccd1 vssd1 X2_sky130_fd_sc_hd__fill_4
XFILLER_21_223 vccd1 vssd1 vccd1 vssd1 X2_sky130_fd_sc_hd__fill_1
XFILLER_1_617 vssd1 vccd1 vccd1 vssd1 X2_sky130_fd_sc_hd__fill_8
XFILLER_88_245 vssd1 vccd1 vccd1 vssd1 X2_sky130_fd_sc_hd__fill_4
XFILLER_88_289 vssd1 vccd1 vssd1 vccd1 X2_sky130_ef_sc_hd__decap_40_12
XFILLER_57_610 vssd1 vccd1 vccd1 vssd1 X2_sky130_fd_sc_hd__fill_2
XFILLER_48_109 vssd1 vccd1 vssd1 vccd1 X2_sky130_ef_sc_hd__decap_40_12
XFILLER_17_529 vssd1 vccd1 vssd1 vccd1 X2_sky130_ef_sc_hd__decap_40_12
XFILLER_84_473 vssd1 vccd1 vccd1 vssd1 X2_sky130_fd_sc_hd__fill_2
XFILLER_56_153 vssd1 vccd1 vssd1 vccd1 X2_sky130_ef_sc_hd__decap_40_12
XTAP_TAPCELL_ROW_27_513 vccd1 vssd1 X2_sky130_fd_sc_hd__tapvpwrvgnd_1
XFILLER_29_389 vssd1 vccd1 vccd1 vssd1 X2_sky130_fd_sc_hd__fill_2
XFILLER_56_197 vssd1 vccd1 vssd1 vccd1 X2_sky130_ef_sc_hd__decap_40_12
XTAP_TAPCELL_ROW_55_822 vccd1 vssd1 X2_sky130_fd_sc_hd__tapvpwrvgnd_1
X_490_ vccd1 vssd1 vccd1 vssd1 _490_/Y _525_/A X2_sky130_fd_sc_hd__inv_2
XFILLER_71_167 vccd1 vssd1 vccd1 vssd1 X2_sky130_fd_sc_hd__fill_1
XANTENNA__527__A _527_/A vssd1 vccd1 vccd1 vssd1 X2_sky130_fd_sc_hd__diode_2
XFILLER_25_573 vssd1 vccd1 vssd1 vccd1 X2_sky130_ef_sc_hd__decap_40_12
XFILLER_44_77 vssd1 vccd1 vccd1 vssd1 X2_sky130_fd_sc_hd__fill_4
XFILLER_12_245 vssd1 vccd1 vccd1 vssd1 X2_sky130_fd_sc_hd__fill_4
XFILLER_8_249 vssd1 vccd1 vccd1 vssd1 X2_sky130_fd_sc_hd__fill_2
XFILLER_12_289 vssd1 vccd1 vssd1 vccd1 X2_sky130_ef_sc_hd__decap_40_12
XFILLER_100_83 vccd1 vssd1 vccd1 vssd1 X2_sky130_fd_sc_hd__fill_1
XFILLER_60_65 vssd1 vccd1 vssd1 vccd1 X2_sky130_ef_sc_hd__decap_40_12
XFILLER_4_433 vssd1 vccd1 vssd1 vccd1 X2_sky130_ef_sc_hd__decap_40_12
XFILLER_5_27 vssd1 vccd1 vssd1 vccd1 X2_sky130_ef_sc_hd__decap_40_12
XFILLER_4_477 vssd1 vccd1 vssd1 vccd1 X2_sky130_ef_sc_hd__decap_40_12
XFILLER_79_223 vccd1 vssd1 vccd1 vssd1 X2_sky130_fd_sc_hd__fill_1
XTAP_TAPCELL_ROW_7_293 vccd1 vssd1 X2_sky130_fd_sc_hd__tapvpwrvgnd_1
XFILLER_39_109 vssd1 vccd1 vccd1 vssd1 X2_sky130_fd_sc_hd__fill_2
XFILLER_67_429 vssd1 vccd1 vssd1 vccd1 X2_sky130_ef_sc_hd__decap_40_12
XFILLER_85_51 vssd1 vccd1 vccd1 vssd1 X2_sky130_fd_sc_hd__fill_4
XFILLER_75_473 vssd1 vccd1 vssd1 vccd1 X2_sky130_ef_sc_hd__decap_40_12
XFILLER_63_613 vssd1 vccd1 vccd1 vssd1 X2_sky130_fd_sc_hd__fill_2
XFILLER_35_326 vssd1 vccd1 vccd1 vssd1 X2_sky130_fd_sc_hd__fill_2
XFILLER_35_337 vccd1 vssd1 vccd1 vssd1 X2_sky130_fd_sc_hd__fill_1
XFILLER_90_421 vssd1 vccd1 vssd1 vccd1 X2_sky130_ef_sc_hd__decap_40_12
XFILLER_63_624 vccd1 vssd1 vccd1 vssd1 X2_sky130_fd_sc_hd__fill_1
XANTENNA__566__CLK _599_/CLK vssd1 vccd1 vccd1 vssd1 X2_sky130_fd_sc_hd__diode_2
XFILLER_62_189 vssd1 vccd1 vccd1 vssd1 X2_sky130_fd_sc_hd__fill_4
XFILLER_79_3 vssd1 vccd1 vssd1 vccd1 X2_sky130_ef_sc_hd__decap_40_12
XFILLER_7_293 vssd1 vccd1 vssd1 vccd1 X2_sky130_ef_sc_hd__decap_40_12
XANTENNA_hold44_A _534_/Q vssd1 vccd1 vccd1 vssd1 X2_sky130_fd_sc_hd__diode_2
XPHY_EDGE_ROW_0_Left_102 vccd1 vssd1 vccd1 vssd1 X2_sky130_fd_sc_hd__decap_3
XPHY_EDGE_ROW_37_Left_139 vccd1 vssd1 vccd1 vssd1 X2_sky130_fd_sc_hd__decap_3
XFILLER_98_587 vccd1 vssd1 vccd1 vssd1 X2_sky130_fd_sc_hd__fill_1
XFILLER_85_237 vssd1 vccd1 vssd1 vccd1 X2_sky130_ef_sc_hd__decap_40_12
XFILLER_38_153 vssd1 vccd1 vccd1 vssd1 X2_sky130_fd_sc_hd__fill_4
XFILLER_66_473 vssd1 vccd1 vccd1 vssd1 X2_sky130_fd_sc_hd__fill_2
XFILLER_54_613 vssd1 vccd1 vccd1 vssd1 X2_sky130_fd_sc_hd__fill_4
XFILLER_38_186 vssd1 vccd1 vccd1 vssd1 X2_sky130_fd_sc_hd__fill_2
XFILLER_38_197 vssd1 vccd1 vssd1 vccd1 X2_sky130_ef_sc_hd__decap_40_12
XFILLER_93_281 vccd1 vssd1 vccd1 vssd1 X2_sky130_fd_sc_hd__fill_1
XFILLER_54_624 vccd1 vssd1 vccd1 vssd1 X2_sky130_fd_sc_hd__fill_1
XFILLER_53_167 vccd1 vssd1 vccd1 vssd1 X2_sky130_fd_sc_hd__fill_1
XTAP_TAPCELL_ROW_101_1338 vccd1 vssd1 X2_sky130_fd_sc_hd__tapvpwrvgnd_1
XTAP_TAPCELL_ROW_101_1327 vccd1 vssd1 X2_sky130_fd_sc_hd__tapvpwrvgnd_1
XPHY_EDGE_ROW_46_Left_148 vccd1 vssd1 vccd1 vssd1 X2_sky130_fd_sc_hd__decap_3
XFILLER_22_587 vccd1 vssd1 vccd1 vssd1 X2_sky130_fd_sc_hd__fill_1
XTAP_TAPCELL_ROW_32_571 vccd1 vssd1 X2_sky130_fd_sc_hd__tapvpwrvgnd_1
XTAP_TAPCELL_ROW_60_880 vccd1 vssd1 X2_sky130_fd_sc_hd__tapvpwrvgnd_1
XFILLER_1_447 vccd1 vssd1 vccd1 vssd1 X2_sky130_fd_sc_hd__fill_1
XFILLER_39_11 vssd1 vccd1 vssd1 vccd1 X2_sky130_ef_sc_hd__decap_40_12
XPHY_EDGE_ROW_55_Left_157 vccd1 vssd1 vccd1 vssd1 X2_sky130_fd_sc_hd__decap_3
XFILLER_39_55 vccd1 vssd1 vccd1 vssd1 X2_sky130_fd_sc_hd__fill_1
XANTENNA__589__CLK _606_/CLK vssd1 vccd1 vccd1 vssd1 X2_sky130_fd_sc_hd__diode_2
XTAP_TAPCELL_ROW_4_263 vccd1 vssd1 X2_sky130_fd_sc_hd__tapvpwrvgnd_1
XFILLER_17_337 vssd1 vccd1 vssd1 vccd1 X2_sky130_ef_sc_hd__decap_40_12
XFILLER_72_421 vssd1 vccd1 vssd1 vccd1 X2_sky130_ef_sc_hd__decap_40_12
XFILLER_57_473 vssd1 vccd1 vssd1 vccd1 X2_sky130_ef_sc_hd__decap_40_12
XFILLER_45_624 vccd1 vssd1 vccd1 vssd1 X2_sky130_fd_sc_hd__fill_1
X_542_ vssd1 vccd1 vccd1 vssd1 _608_/CLK _542_/D _462_/Y _542_/Q X2_sky130_fd_sc_hd__dfrtp_1
XFILLER_32_307 vccd1 vssd1 vccd1 vssd1 X2_sky130_fd_sc_hd__fill_1
XTAP_TAPCELL_ROW_80_1102 vccd1 vssd1 X2_sky130_fd_sc_hd__tapvpwrvgnd_1
XPHY_EDGE_ROW_64_Left_166 vccd1 vssd1 vccd1 vssd1 X2_sky130_fd_sc_hd__decap_3
X_473_ vccd1 vssd1 vccd1 vssd1 _473_/Y _473_/A X2_sky130_fd_sc_hd__inv_2
XFILLER_44_189 vssd1 vccd1 vccd1 vssd1 X2_sky130_fd_sc_hd__fill_4
XFILLER_9_503 vccd1 vssd1 vccd1 vssd1 X2_sky130_fd_sc_hd__fill_1
XFILLER_40_351 vssd1 vccd1 vccd1 vssd1 X2_sky130_fd_sc_hd__fill_2
XTAP_TAPCELL_ROW_78_1075 vccd1 vssd1 X2_sky130_fd_sc_hd__tapvpwrvgnd_1
XTAP_TAPCELL_ROW_91_1220 vccd1 vssd1 X2_sky130_fd_sc_hd__tapvpwrvgnd_1
XPHY_EDGE_ROW_73_Left_175 vccd1 vssd1 vccd1 vssd1 X2_sky130_fd_sc_hd__decap_3
XFILLER_95_557 vssd1 vccd1 vccd1 vssd1 X2_sky130_fd_sc_hd__fill_2
XFILLER_96_83 vccd1 vssd1 vccd1 vssd1 X2_sky130_fd_sc_hd__fill_1
XFILLER_67_237 vssd1 vccd1 vssd1 vccd1 X2_sky130_ef_sc_hd__decap_40_12
XFILLER_36_624 vccd1 vssd1 vccd1 vssd1 X2_sky130_fd_sc_hd__fill_1
XFILLER_75_281 vssd1 vccd1 vssd1 vccd1 X2_sky130_ef_sc_hd__decap_40_12
XFILLER_48_484 vssd1 vccd1 vssd1 vccd1 X2_sky130_ef_sc_hd__decap_40_12
XFILLER_48_473 vssd1 vccd1 vccd1 vssd1 X2_sky130_fd_sc_hd__fill_2
XPHY_EDGE_ROW_82_Left_184 vccd1 vssd1 vccd1 vssd1 X2_sky130_fd_sc_hd__decap_3
XFILLER_23_329 vssd1 vccd1 vccd1 vssd1 X2_sky130_fd_sc_hd__fill_4
XFILLER_35_167 vccd1 vssd1 vccd1 vssd1 X2_sky130_fd_sc_hd__fill_1
XFILLER_90_251 vccd1 vssd1 vccd1 vssd1 X2_sky130_fd_sc_hd__fill_1
XFILLER_50_137 vssd1 vccd1 vccd1 vssd1 X2_sky130_fd_sc_hd__fill_2
XFILLER_31_362 vssd1 vccd1 vssd1 vccd1 X2_sky130_ef_sc_hd__decap_40_12
XPHY_EDGE_ROW_91_Left_193 vccd1 vssd1 vccd1 vssd1 X2_sky130_fd_sc_hd__decap_3
XFILLER_6_81 vssd1 vccd1 vccd1 vssd1 X2_sky130_fd_sc_hd__fill_2
XFILLER_86_513 vssd1 vccd1 vssd1 vccd1 X2_sky130_ef_sc_hd__decap_40_12
XFILLER_86_557 vssd1 vccd1 vssd1 vccd1 X2_sky130_ef_sc_hd__decap_40_12
XFILLER_98_395 vccd1 vssd1 vccd1 vssd1 X2_sky130_fd_sc_hd__fill_1
XFILLER_100_367 vccd1 vssd1 vccd1 vssd1 X2_sky130_fd_sc_hd__fill_1
XFILLER_100_345 vssd1 vccd1 vccd1 vssd1 X2_sky130_fd_sc_hd__fill_2
XTAP_TAPCELL_ROW_1_233 vccd1 vssd1 X2_sky130_fd_sc_hd__tapvpwrvgnd_1
XFILLER_27_613 vssd1 vccd1 vccd1 vssd1 X2_sky130_fd_sc_hd__fill_2
XFILLER_39_473 vssd1 vccd1 vssd1 vccd1 X2_sky130_ef_sc_hd__decap_40_12
XFILLER_54_421 vssd1 vccd1 vccd1 vssd1 X2_sky130_fd_sc_hd__fill_8
XTAP_TAPCELL_ROW_37_630 vccd1 vssd1 X2_sky130_fd_sc_hd__tapvpwrvgnd_1
XFILLER_14_307 vccd1 vssd1 vccd1 vssd1 X2_sky130_fd_sc_hd__fill_1
XFILLER_26_189 vssd1 vccd1 vccd1 vssd1 X2_sky130_fd_sc_hd__fill_4
XFILLER_81_273 vssd1 vccd1 vccd1 vssd1 X2_sky130_fd_sc_hd__fill_4
XFILLER_54_498 vssd1 vccd1 vssd1 vccd1 X2_sky130_ef_sc_hd__decap_40_12
XFILLER_42_605 vssd1 vccd1 vccd1 vssd1 X2_sky130_fd_sc_hd__fill_2
XFILLER_25_57 vssd1 vccd1 vssd1 vccd1 X2_sky130_ef_sc_hd__decap_40_12
XFILLER_41_137 vssd1 vccd1 vssd1 vccd1 X2_sky130_ef_sc_hd__decap_40_12
XFILLER_10_513 vssd1 vccd1 vssd1 vccd1 X2_sky130_ef_sc_hd__decap_40_12
XFILLER_10_557 vssd1 vccd1 vssd1 vccd1 X2_sky130_ef_sc_hd__decap_40_12
XTAP_TAPCELL_ROW_9_322 vccd1 vssd1 X2_sky130_fd_sc_hd__tapvpwrvgnd_1
XFILLER_9_3 vssd1 vccd1 vssd1 vccd1 X2_sky130_ef_sc_hd__decap_40_12
XFILLER_89_373 vssd1 vccd1 vssd1 vccd1 X2_sky130_ef_sc_hd__decap_40_12
XFILLER_77_557 vssd1 vccd1 vccd1 vssd1 X2_sky130_fd_sc_hd__fill_2
XFILLER_49_237 vssd1 vccd1 vssd1 vccd1 X2_sky130_ef_sc_hd__decap_40_12
XFILLER_66_53 vssd1 vccd1 vssd1 vccd1 X2_sky130_ef_sc_hd__decap_40_12
XFILLER_18_613 vssd1 vccd1 vssd1 vccd1 X2_sky130_ef_sc_hd__decap_40_12
XFILLER_66_97 vssd1 vccd1 vssd1 vccd1 X2_sky130_ef_sc_hd__decap_40_12
XFILLER_57_281 vssd1 vccd1 vccd1 vssd1 X2_sky130_fd_sc_hd__fill_4
XTAP_TAPCELL_ROW_63_909 vccd1 vssd1 X2_sky130_fd_sc_hd__tapvpwrvgnd_1
XFILLER_45_443 vssd1 vccd1 vccd1 vssd1 X2_sky130_fd_sc_hd__fill_2
XFILLER_17_167 vccd1 vssd1 vccd1 vssd1 X2_sky130_fd_sc_hd__fill_1
XFILLER_33_605 vccd1 vssd1 vccd1 vssd1 X2_sky130_fd_sc_hd__fill_1
XFILLER_82_41 vssd1 vccd1 vssd1 vccd1 X2_sky130_ef_sc_hd__decap_40_12
XFILLER_72_251 vccd1 vssd1 vccd1 vssd1 X2_sky130_fd_sc_hd__fill_1
X_525_ vccd1 vssd1 vccd1 vssd1 _525_/Y _525_/A X2_sky130_fd_sc_hd__inv_2
XFILLER_60_413 vssd1 vccd1 vccd1 vssd1 X2_sky130_fd_sc_hd__fill_4
XFILLER_32_137 vssd1 vccd1 vccd1 vssd1 X2_sky130_fd_sc_hd__fill_2
X_456_ vccd1 vssd1 vccd1 vssd1 _456_/Y _473_/A X2_sky130_fd_sc_hd__inv_2
XFILLER_82_85 vssd1 vccd1 vssd1 vccd1 X2_sky130_ef_sc_hd__decap_40_12
XFILLER_60_457 vssd1 vccd1 vssd1 vccd1 X2_sky130_ef_sc_hd__decap_40_12
XFILLER_9_333 vssd1 vccd1 vccd1 vssd1 X2_sky130_fd_sc_hd__fill_2
XFILLER_13_373 vssd1 vccd1 vssd1 vccd1 X2_sky130_ef_sc_hd__decap_40_12
XTAP_TAPCELL_ROW_71_997 vccd1 vssd1 X2_sky130_fd_sc_hd__tapvpwrvgnd_1
XANTENNA__604__CLK _606_/CLK vssd1 vccd1 vccd1 vssd1 X2_sky130_fd_sc_hd__diode_2
X_387_ _387_/X _537_/Q _552_/Q vssd1 vccd1 vccd1 vssd1 X2_sky130_fd_sc_hd__and2b_1
XTAP_TAPCELL_ROW_43_688 vccd1 vssd1 X2_sky130_fd_sc_hd__tapvpwrvgnd_1
XFILLER_5_561 vssd1 vccd1 vssd1 vccd1 X2_sky130_ef_sc_hd__decap_40_12
XFILLER_99_137 vssd1 vccd1 vssd1 vccd1 X2_sky130_ef_sc_hd__decap_40_12
XFILLER_101_109 vssd1 vccd1 vccd1 vssd1 X2_sky130_fd_sc_hd__fill_2
XFILLER_68_513 vssd1 vccd1 vssd1 vccd1 X2_sky130_ef_sc_hd__decap_40_12
XFILLER_68_557 vssd1 vccd1 vssd1 vccd1 X2_sky130_ef_sc_hd__decap_40_12
XFILLER_95_354 vssd1 vccd1 vssd1 vccd1 X2_sky130_ef_sc_hd__decap_40_12
XFILLER_95_376 vccd1 vssd1 vccd1 vssd1 X2_sky130_fd_sc_hd__fill_1
XFILLER_83_505 vssd1 vccd1 vssd1 vccd1 X2_sky130_ef_sc_hd__decap_40_12
XFILLER_36_421 vccd1 vssd1 vccd1 vssd1 X2_sky130_fd_sc_hd__fill_1
XFILLER_63_273 vccd1 vssd1 vccd1 vssd1 X2_sky130_fd_sc_hd__fill_1
XFILLER_23_137 vssd1 vccd1 vssd1 vccd1 X2_sky130_ef_sc_hd__decap_40_12
XFILLER_31_181 vssd1 vccd1 vssd1 vccd1 X2_sky130_ef_sc_hd__decap_40_12
XFILLER_11_15 vssd1 vccd1 vssd1 vccd1 X2_sky130_ef_sc_hd__decap_40_12
XFILLER_86_321 vssd1 vccd1 vssd1 vccd1 X2_sky130_ef_sc_hd__decap_40_12
XFILLER_86_365 vssd1 vccd1 vssd1 vccd1 X2_sky130_ef_sc_hd__decap_40_12
XFILLER_59_557 vssd1 vccd1 vccd1 vssd1 X2_sky130_fd_sc_hd__fill_2
XFILLER_100_153 vssd1 vccd1 vssd1 vccd1 X2_sky130_ef_sc_hd__decap_40_12
XFILLER_39_281 vccd1 vssd1 vccd1 vssd1 X2_sky130_fd_sc_hd__fill_1
XFILLER_100_197 vssd1 vccd1 vssd1 vccd1 X2_sky130_ef_sc_hd__decap_40_12
XFILLER_14_137 vssd1 vccd1 vccd1 vssd1 X2_sky130_fd_sc_hd__fill_2
X_310_ vccd1 vssd1 vssd1 vccd1 _320_/B _310_/B _440_/B _310_/Y X2_sky130_fd_sc_hd__nor3_2
XFILLER_42_424 vssd1 vccd1 vccd1 vssd1 X2_sky130_fd_sc_hd__fill_4
XFILLER_42_457 vssd1 vccd1 vssd1 vccd1 X2_sky130_ef_sc_hd__decap_40_12
XFILLER_10_321 vssd1 vccd1 vssd1 vccd1 X2_sky130_ef_sc_hd__decap_40_12
XTAP_TAPCELL_ROW_12_349 vccd1 vssd1 X2_sky130_fd_sc_hd__tapvpwrvgnd_1
XTAP_TAPCELL_ROW_40_658 vccd1 vssd1 X2_sky130_fd_sc_hd__tapvpwrvgnd_1
XFILLER_52_77 vssd1 vccd1 vccd1 vssd1 X2_sky130_fd_sc_hd__fill_4
XFILLER_10_365 vssd1 vccd1 vssd1 vccd1 X2_sky130_ef_sc_hd__decap_40_12
XFILLER_2_531 vccd1 vssd1 vccd1 vssd1 X2_sky130_fd_sc_hd__fill_1
XTAP_TAPCELL_ROW_75_1045 vccd1 vssd1 X2_sky130_fd_sc_hd__tapvpwrvgnd_1
XFILLER_89_181 vssd1 vccd1 vssd1 vccd1 X2_sky130_ef_sc_hd__decap_40_12
XFILLER_65_505 vssd1 vccd1 vssd1 vccd1 X2_sky130_ef_sc_hd__decap_40_12
XFILLER_18_421 vssd1 vccd1 vssd1 vccd1 X2_sky130_ef_sc_hd__decap_40_12
XFILLER_93_51 vssd1 vccd1 vccd1 vssd1 X2_sky130_fd_sc_hd__fill_4
XTAP_TAPCELL_ROW_48_747 vccd1 vssd1 X2_sky130_fd_sc_hd__tapvpwrvgnd_1
XTAP_TAPCELL_ROW_86_1163 vccd1 vssd1 X2_sky130_fd_sc_hd__tapvpwrvgnd_1
XFILLER_45_240 vssd1 vccd1 vccd1 vssd1 X2_sky130_fd_sc_hd__fill_2
XFILLER_60_221 vssd1 vccd1 vssd1 vccd1 X2_sky130_ef_sc_hd__decap_40_12
XFILLER_45_273 vssd1 vccd1 vccd1 vssd1 X2_sky130_fd_sc_hd__fill_4
X_508_ vccd1 vssd1 vccd1 vssd1 _508_/Y _527_/A X2_sky130_fd_sc_hd__inv_2
X_439_ vssd1 vccd1 _573_/Q _607_/Q _439_/X _574_/Q hold3/X vccd1 vssd1 X2_sky130_fd_sc_hd__and4b_1
XFILLER_13_181 vssd1 vccd1 vssd1 vccd1 X2_sky130_ef_sc_hd__decap_40_12
XFILLER_61_3 vssd1 vccd1 vssd1 vccd1 X2_sky130_ef_sc_hd__decap_40_12
XTAP_TAPCELL_ROW_97_1292 vccd1 vssd1 X2_sky130_fd_sc_hd__tapvpwrvgnd_1
XFILLER_5_391 vccd1 vssd1 vccd1 vssd1 X2_sky130_fd_sc_hd__fill_1
XFILLER_68_365 vssd1 vccd1 vssd1 vccd1 X2_sky130_ef_sc_hd__decap_40_12
XFILLER_68_343 vssd1 vccd1 vssd1 vccd1 X2_sky130_ef_sc_hd__decap_40_12
XFILLER_3_93 vssd1 vccd1 vssd1 vccd1 X2_sky130_ef_sc_hd__decap_40_12
XFILLER_83_335 vccd1 vssd1 vccd1 vssd1 X2_sky130_fd_sc_hd__fill_1
XFILLER_36_251 vccd1 vssd1 vccd1 vssd1 X2_sky130_fd_sc_hd__fill_1
XFILLER_24_413 vssd1 vccd1 vccd1 vssd1 X2_sky130_fd_sc_hd__fill_4
XFILLER_36_295 vssd1 vccd1 vssd1 vccd1 X2_sky130_ef_sc_hd__decap_40_12
XFILLER_24_457 vssd1 vccd1 vssd1 vccd1 X2_sky130_ef_sc_hd__decap_40_12
XFILLER_51_232 vssd1 vccd1 vssd1 vccd1 X2_sky130_ef_sc_hd__decap_40_12
XFILLER_51_276 vssd1 vccd1 vccd1 vssd1 X2_sky130_fd_sc_hd__fill_4
XFILLER_3_317 vssd1 vccd1 vssd1 vccd1 X2_sky130_ef_sc_hd__decap_40_12
XFILLER_98_29 vssd1 vccd1 vssd1 vccd1 X2_sky130_ef_sc_hd__decap_40_12
XFILLER_59_343 vccd1 vssd1 vccd1 vssd1 X2_sky130_fd_sc_hd__fill_1
XFILLER_47_505 vccd1 vssd1 vccd1 vssd1 X2_sky130_fd_sc_hd__fill_1
XFILLER_47_11 vssd1 vccd1 vssd1 vccd1 X2_sky130_ef_sc_hd__decap_40_12
XFILLER_101_473 vssd1 vccd1 vccd1 vssd1 X2_sky130_fd_sc_hd__fill_2
XFILLER_47_55 vccd1 vssd1 vccd1 vssd1 X2_sky130_fd_sc_hd__fill_1
XFILLER_86_195 vccd1 vssd1 vccd1 vssd1 X2_sky130_fd_sc_hd__fill_1
XFILLER_74_357 vssd1 vccd1 vccd1 vssd1 X2_sky130_fd_sc_hd__fill_4
XTAP_TAPCELL_ROW_17_408 vccd1 vssd1 X2_sky130_fd_sc_hd__tapvpwrvgnd_1
XTAP_TAPCELL_ROW_45_717 vccd1 vssd1 X2_sky130_fd_sc_hd__tapvpwrvgnd_1
XFILLER_27_273 vssd1 vccd1 vccd1 vssd1 X2_sky130_fd_sc_hd__fill_4
XFILLER_70_585 vssd1 vccd1 vccd1 vssd1 X2_sky130_fd_sc_hd__fill_2
XFILLER_42_265 vssd1 vccd1 vssd1 vccd1 X2_sky130_ef_sc_hd__decap_40_12
XFILLER_8_27 vccd1 vssd1 vccd1 vssd1 X2_sky130_fd_sc_hd__fill_1
XTAP_TAPCELL_ROW_25_496 vccd1 vssd1 X2_sky130_fd_sc_hd__tapvpwrvgnd_1
XFILLER_6_133 vssd1 vccd1 vccd1 vssd1 X2_sky130_fd_sc_hd__fill_4
XFILLER_10_195 vccd1 vssd1 vccd1 vssd1 X2_sky130_fd_sc_hd__fill_1
XFILLER_6_177 vssd1 vccd1 vssd1 vccd1 X2_sky130_ef_sc_hd__decap_40_12
XFILLER_97_405 vccd1 vssd1 vccd1 vssd1 X2_sky130_fd_sc_hd__fill_1
XFILLER_2_361 vssd1 vccd1 vccd1 vssd1 X2_sky130_fd_sc_hd__fill_2
XFILLER_97_449 vssd1 vccd1 vssd1 vccd1 X2_sky130_ef_sc_hd__decap_40_12
Xtop_soc_75 wbs_dat_o[23] top_soc_75/HI vccd1 vssd1 vssd1 vccd1 X2_sky130_fd_sc_hd__conb_1
XFILLER_92_121 vssd1 vccd1 vssd1 vccd1 X2_sky130_ef_sc_hd__decap_40_12
XFILLER_65_335 vccd1 vssd1 vccd1 vssd1 X2_sky130_fd_sc_hd__fill_1
XFILLER_18_251 vccd1 vssd1 vccd1 vssd1 X2_sky130_fd_sc_hd__fill_1
XFILLER_92_165 vssd1 vccd1 vssd1 vccd1 X2_sky130_ef_sc_hd__decap_40_12
XFILLER_80_305 vssd1 vccd1 vccd1 vssd1 X2_sky130_fd_sc_hd__fill_2
XFILLER_46_560 vssd1 vccd1 vssd1 vccd1 X2_sky130_ef_sc_hd__decap_40_12
XFILLER_61_541 vssd1 vccd1 vssd1 vccd1 X2_sky130_ef_sc_hd__decap_40_12
XFILLER_21_405 vssd1 vccd1 vssd1 vccd1 X2_sky130_ef_sc_hd__decap_40_12
XFILLER_61_596 vssd1 vccd1 vccd1 vssd1 X2_sky130_fd_sc_hd__fill_2
XFILLER_21_449 vssd1 vccd1 vssd1 vccd1 X2_sky130_ef_sc_hd__decap_40_12
XTAP_TAPCELL_ROW_99_1310 vccd1 vssd1 X2_sky130_fd_sc_hd__tapvpwrvgnd_1
XFILLER_0_309 vssd1 vccd1 vccd1 vssd1 X2_sky130_fd_sc_hd__fill_8
XFILLER_88_416 vssd1 vccd1 vccd1 vssd1 X2_sky130_fd_sc_hd__fill_4
XFILLER_29_505 vssd1 vccd1 vssd1 vccd1 X2_sky130_ef_sc_hd__decap_40_12
XFILLER_68_195 vccd1 vssd1 vccd1 vssd1 X2_sky130_fd_sc_hd__fill_1
XFILLER_83_165 vssd1 vccd1 vccd1 vssd1 X2_sky130_fd_sc_hd__fill_2
XFILLER_71_305 vssd1 vccd1 vssd1 vccd1 X2_sky130_ef_sc_hd__decap_40_12
XFILLER_44_519 vssd1 vccd1 vccd1 vssd1 X2_sky130_fd_sc_hd__fill_2
XFILLER_17_69 vssd1 vccd1 vssd1 vccd1 X2_sky130_ef_sc_hd__decap_40_12
XFILLER_37_593 vssd1 vccd1 vccd1 vssd1 X2_sky130_fd_sc_hd__fill_2
XFILLER_71_349 vssd1 vccd1 vssd1 vccd1 X2_sky130_ef_sc_hd__decap_40_12
XFILLER_24_221 vssd1 vccd1 vssd1 vccd1 X2_sky130_ef_sc_hd__decap_40_12
XFILLER_52_530 vssd1 vccd1 vccd1 vssd1 X2_sky130_fd_sc_hd__fill_2
XFILLER_24_265 vssd1 vccd1 vssd1 vccd1 X2_sky130_ef_sc_hd__decap_40_12
XFILLER_33_57 vssd1 vccd1 vssd1 vccd1 X2_sky130_ef_sc_hd__decap_40_12
XTAP_TAPCELL_ROW_22_466 vccd1 vssd1 X2_sky130_fd_sc_hd__tapvpwrvgnd_1
XTAP_TAPCELL_ROW_50_775 vccd1 vssd1 X2_sky130_fd_sc_hd__tapvpwrvgnd_1
XFILLER_3_125 vssd1 vccd1 vssd1 vccd1 X2_sky130_ef_sc_hd__decap_40_12
XFILLER_3_169 vssd1 vccd1 vssd1 vccd1 X2_sky130_ef_sc_hd__decap_40_12
XFILLER_79_405 vssd1 vccd1 vssd1 vccd1 X2_sky130_ef_sc_hd__decap_40_12
XTAP_TAPCELL_ROW_72_1015 vccd1 vssd1 X2_sky130_fd_sc_hd__tapvpwrvgnd_1
XFILLER_79_449 vssd1 vccd1 vssd1 vccd1 X2_sky130_ef_sc_hd__decap_40_12
XFILLER_58_65 vssd1 vccd1 vssd1 vccd1 X2_sky130_ef_sc_hd__decap_40_12
XFILLER_94_419 vccd1 vssd1 vccd1 vssd1 X2_sky130_fd_sc_hd__fill_1
Xhold9 hold9/X hold9/A vccd1 vssd1 vssd1 vccd1 X2_sky130_fd_sc_hd__dlygate4sd3_1
XFILLER_47_302 vssd1 vccd1 vccd1 vssd1 X2_sky130_fd_sc_hd__fill_8
XFILLER_101_281 vssd1 vccd1 vssd1 vccd1 X2_sky130_ef_sc_hd__decap_40_12
XFILLER_74_121 vssd1 vccd1 vssd1 vccd1 X2_sky130_ef_sc_hd__decap_40_12
XANTENNA_input29_A wbs_dat_i[15] vssd1 vccd1 vccd1 vssd1 X2_sky130_fd_sc_hd__diode_2
XFILLER_47_335 vccd1 vssd1 vccd1 vssd1 X2_sky130_fd_sc_hd__fill_1
XFILLER_74_165 vssd1 vccd1 vssd1 vccd1 X2_sky130_ef_sc_hd__decap_40_12
XFILLER_62_305 vssd1 vccd1 vccd1 vssd1 X2_sky130_fd_sc_hd__fill_2
XTAP_TAPCELL_ROW_58_853 vccd1 vssd1 X2_sky130_fd_sc_hd__tapvpwrvgnd_1
XFILLER_74_53 vssd1 vccd1 vssd1 vccd1 X2_sky130_ef_sc_hd__decap_40_12
XFILLER_15_221 vssd1 vccd1 vccd1 vssd1 X2_sky130_fd_sc_hd__fill_2
XTAP_TAPCELL_ROW_83_1133 vccd1 vssd1 X2_sky130_fd_sc_hd__tapvpwrvgnd_1
XFILLER_74_97 vssd1 vccd1 vssd1 vccd1 X2_sky130_ef_sc_hd__decap_40_12
XFILLER_90_41 vssd1 vccd1 vssd1 vccd1 X2_sky130_ef_sc_hd__decap_40_12
XFILLER_90_85 vssd1 vccd1 vssd1 vccd1 X2_sky130_ef_sc_hd__decap_40_12
XFILLER_7_497 vssd1 vccd1 vccd1 vssd1 X2_sky130_fd_sc_hd__fill_4
XANTENNA__314__B1 _304_/X vssd1 vccd1 vccd1 vssd1 X2_sky130_fd_sc_hd__diode_2
XTAP_TAPCELL_ROW_94_1251 vccd1 vssd1 X2_sky130_fd_sc_hd__tapvpwrvgnd_1
XFILLER_24_3 vssd1 vccd1 vssd1 vccd1 X2_sky130_ef_sc_hd__decap_40_12
XFILLER_38_313 vssd1 vccd1 vccd1 vssd1 X2_sky130_fd_sc_hd__fill_2
XFILLER_97_279 vccd1 vssd1 vccd1 vssd1 X2_sky130_fd_sc_hd__fill_1
XFILLER_93_441 vssd1 vccd1 vccd1 vssd1 X2_sky130_fd_sc_hd__fill_4
XFILLER_65_165 vssd1 vccd1 vccd1 vssd1 X2_sky130_fd_sc_hd__fill_2
XFILLER_53_305 vssd1 vccd1 vssd1 vccd1 X2_sky130_ef_sc_hd__decap_40_12
XFILLER_93_485 vssd1 vccd1 vssd1 vccd1 X2_sky130_ef_sc_hd__decap_40_12
XFILLER_0_83 vccd1 vssd1 vccd1 vssd1 X2_sky130_fd_sc_hd__fill_1
XFILLER_61_393 vssd1 vccd1 vssd1 vccd1 X2_sky130_ef_sc_hd__decap_40_12
XFILLER_9_81 vssd1 vccd1 vssd1 vccd1 X2_sky130_ef_sc_hd__decap_40_12
XFILLER_21_279 vccd1 vssd1 vccd1 vssd1 X2_sky130_fd_sc_hd__fill_1
XANTENNA__305__B1 _304_/X vssd1 vccd1 vccd1 vssd1 X2_sky130_fd_sc_hd__diode_2
XFILLER_0_139 vccd1 vssd1 vccd1 vssd1 X2_sky130_fd_sc_hd__fill_1
XFILLER_76_419 vccd1 vssd1 vccd1 vssd1 X2_sky130_fd_sc_hd__fill_1
XFILLER_29_335 vccd1 vssd1 vccd1 vssd1 X2_sky130_fd_sc_hd__fill_1
XFILLER_56_121 vssd1 vccd1 vssd1 vccd1 X2_sky130_ef_sc_hd__decap_40_12
XFILLER_56_165 vssd1 vccd1 vssd1 vccd1 X2_sky130_ef_sc_hd__decap_40_12
XFILLER_44_305 vssd1 vccd1 vccd1 vssd1 X2_sky130_fd_sc_hd__fill_2
XTAP_TAPCELL_ROW_27_514 vccd1 vssd1 X2_sky130_fd_sc_hd__tapvpwrvgnd_1
XFILLER_71_113 vssd1 vccd1 vssd1 vccd1 X2_sky130_ef_sc_hd__decap_40_12
XTAP_TAPCELL_ROW_55_823 vccd1 vssd1 X2_sky130_fd_sc_hd__tapvpwrvgnd_1
XFILLER_25_541 vssd1 vccd1 vssd1 vccd1 X2_sky130_ef_sc_hd__decap_40_12
XFILLER_25_585 vssd1 vccd1 vssd1 vccd1 X2_sky130_ef_sc_hd__decap_40_12
XFILLER_40_533 vccd1 vssd1 vccd1 vssd1 X2_sky130_fd_sc_hd__fill_1
XFILLER_60_77 vssd1 vccd1 vccd1 vssd1 X2_sky130_fd_sc_hd__fill_4
XFILLER_4_401 vssd1 vccd1 vssd1 vccd1 X2_sky130_ef_sc_hd__decap_40_12
XFILLER_4_445 vssd1 vccd1 vssd1 vccd1 X2_sky130_ef_sc_hd__decap_40_12
XFILLER_5_39 vssd1 vccd1 vssd1 vccd1 X2_sky130_ef_sc_hd__decap_40_12
XFILLER_4_489 vssd1 vccd1 vssd1 vccd1 X2_sky130_ef_sc_hd__decap_40_12
XFILLER_79_279 vccd1 vssd1 vccd1 vssd1 X2_sky130_fd_sc_hd__fill_1
XTAP_TAPCELL_ROW_7_294 vccd1 vssd1 X2_sky130_fd_sc_hd__tapvpwrvgnd_1
XFILLER_94_249 vssd1 vccd1 vccd1 vssd1 X2_sky130_fd_sc_hd__fill_2
XFILLER_75_441 vssd1 vccd1 vccd1 vssd1 X2_sky130_fd_sc_hd__fill_4
XFILLER_75_485 vssd1 vccd1 vssd1 vccd1 X2_sky130_ef_sc_hd__decap_40_12
XFILLER_47_165 vssd1 vccd1 vccd1 vssd1 X2_sky130_fd_sc_hd__fill_2
XFILLER_90_433 vssd1 vccd1 vssd1 vccd1 X2_sky130_ef_sc_hd__decap_40_12
XFILLER_16_585 vssd1 vccd1 vccd1 vssd1 X2_sky130_fd_sc_hd__fill_2
XFILLER_90_477 vssd1 vccd1 vssd1 vccd1 X2_sky130_ef_sc_hd__decap_40_12
XFILLER_43_393 vssd1 vccd1 vccd1 vssd1 X2_sky130_fd_sc_hd__fill_8
XFILLER_43_382 vssd1 vccd1 vccd1 vssd1 X2_sky130_fd_sc_hd__fill_8
XANTENNA__453__A _473_/A vssd1 vccd1 vccd1 vssd1 X2_sky130_fd_sc_hd__diode_2
XFILLER_7_261 vssd1 vccd1 vssd1 vccd1 X2_sky130_ef_sc_hd__decap_40_12
XFILLER_98_533 vssd1 vccd1 vssd1 vccd1 X2_sky130_ef_sc_hd__decap_40_12
XPHY_EDGE_ROW_7_Right_7 vccd1 vssd1 vccd1 vssd1 X2_sky130_fd_sc_hd__decap_3
XFILLER_39_611 vccd1 vssd1 vccd1 vssd1 X2_sky130_fd_sc_hd__fill_1
XFILLER_85_205 vssd1 vccd1 vssd1 vccd1 X2_sky130_ef_sc_hd__decap_40_12
XFILLER_58_419 vccd1 vssd1 vccd1 vssd1 X2_sky130_fd_sc_hd__fill_1
XFILLER_38_121 vssd1 vccd1 vssd1 vccd1 X2_sky130_ef_sc_hd__decap_40_12
XFILLER_85_249 vssd1 vccd1 vssd1 vccd1 X2_sky130_ef_sc_hd__decap_40_12
XFILLER_26_305 vssd1 vccd1 vccd1 vssd1 X2_sky130_fd_sc_hd__fill_2
XFILLER_53_113 vssd1 vccd1 vssd1 vccd1 X2_sky130_ef_sc_hd__decap_40_12
XFILLER_14_15 vssd1 vccd1 vssd1 vccd1 X2_sky130_ef_sc_hd__decap_40_12
XFILLER_22_533 vssd1 vccd1 vssd1 vccd1 X2_sky130_ef_sc_hd__decap_40_12
XTAP_TAPCELL_ROW_101_1339 vccd1 vssd1 X2_sky130_fd_sc_hd__tapvpwrvgnd_1
XTAP_TAPCELL_ROW_101_1328 vccd1 vssd1 X2_sky130_fd_sc_hd__tapvpwrvgnd_1
XPHY_EDGE_ROW_101_Left_203 vccd1 vssd1 vccd1 vssd1 X2_sky130_fd_sc_hd__decap_3
XTAP_TAPCELL_ROW_32_572 vccd1 vssd1 X2_sky130_fd_sc_hd__tapvpwrvgnd_1
XTAP_TAPCELL_ROW_60_881 vccd1 vssd1 X2_sky130_fd_sc_hd__tapvpwrvgnd_1
XFILLER_39_23 vssd1 vccd1 vssd1 vccd1 X2_sky130_ef_sc_hd__decap_40_12
XFILLER_49_419 vssd1 vccd1 vccd1 vssd1 X2_sky130_fd_sc_hd__fill_8
XFILLER_76_249 vssd1 vccd1 vccd1 vssd1 X2_sky130_fd_sc_hd__fill_2
XTAP_TAPCELL_ROW_4_264 vccd1 vssd1 X2_sky130_fd_sc_hd__tapvpwrvgnd_1
XFILLER_57_441 vssd1 vccd1 vccd1 vssd1 X2_sky130_fd_sc_hd__fill_4
XFILLER_17_305 vssd1 vccd1 vssd1 vccd1 X2_sky130_ef_sc_hd__decap_40_12
XFILLER_29_165 vssd1 vccd1 vccd1 vssd1 X2_sky130_fd_sc_hd__fill_2
XTAP_TAPCELL_ROW_68_970 vccd1 vssd1 X2_sky130_fd_sc_hd__tapvpwrvgnd_1
X_541_ vssd1 vccd1 vccd1 vssd1 _601_/CLK _541_/D _461_/Y _541_/Q X2_sky130_fd_sc_hd__dfrtp_4
XFILLER_57_485 vssd1 vccd1 vssd1 vccd1 X2_sky130_ef_sc_hd__decap_40_12
XFILLER_17_349 vssd1 vccd1 vssd1 vccd1 X2_sky130_ef_sc_hd__decap_40_12
XFILLER_72_433 vssd1 vccd1 vssd1 vccd1 X2_sky130_ef_sc_hd__decap_40_12
XFILLER_55_55 vccd1 vssd1 vccd1 vssd1 X2_sky130_fd_sc_hd__fill_1
XFILLER_72_477 vssd1 vccd1 vssd1 vccd1 X2_sky130_ef_sc_hd__decap_40_12
X_472_ vccd1 vssd1 vccd1 vssd1 _472_/Y _473_/A X2_sky130_fd_sc_hd__inv_2
XFILLER_25_393 vssd1 vccd1 vssd1 vccd1 X2_sky130_ef_sc_hd__decap_40_12
XTAP_TAPCELL_ROW_80_1103 vccd1 vssd1 X2_sky130_fd_sc_hd__tapvpwrvgnd_1
XFILLER_40_330 vssd1 vccd1 vssd1 vccd1 X2_sky130_ef_sc_hd__decap_40_12
XFILLER_9_559 vccd1 vssd1 vccd1 vssd1 X2_sky130_fd_sc_hd__fill_1
XFILLER_40_374 vssd1 vccd1 vssd1 vccd1 X2_sky130_ef_sc_hd__decap_40_12
XTAP_TAPCELL_ROW_78_1076 vccd1 vssd1 X2_sky130_fd_sc_hd__tapvpwrvgnd_1
XFILLER_4_253 vssd1 vccd1 vssd1 vccd1 X2_sky130_ef_sc_hd__decap_40_12
XTAP_TAPCELL_ROW_91_1221 vccd1 vssd1 X2_sky130_fd_sc_hd__tapvpwrvgnd_1
XANTENNA__533__CLK _553_/CLK vssd1 vccd1 vccd1 vssd1 X2_sky130_fd_sc_hd__diode_2
XFILLER_95_503 vccd1 vssd1 vccd1 vssd1 X2_sky130_fd_sc_hd__fill_1
XFILLER_67_205 vssd1 vccd1 vssd1 vccd1 X2_sky130_ef_sc_hd__decap_40_12
XFILLER_67_249 vssd1 vccd1 vssd1 vccd1 X2_sky130_ef_sc_hd__decap_40_12
XFILLER_48_452 vssd1 vccd1 vccd1 vssd1 X2_sky130_fd_sc_hd__fill_2
XFILLER_35_113 vssd1 vccd1 vssd1 vccd1 X2_sky130_ef_sc_hd__decap_40_12
XFILLER_48_496 vssd1 vccd1 vccd1 vssd1 X2_sky130_fd_sc_hd__fill_2
XTAP_TAPCELL_ROW_89_1194 vccd1 vssd1 X2_sky130_fd_sc_hd__tapvpwrvgnd_1
XFILLER_75_293 vssd1 vccd1 vssd1 vccd1 X2_sky130_ef_sc_hd__decap_40_12
XFILLER_63_477 vssd1 vccd1 vssd1 vccd1 X2_sky130_ef_sc_hd__decap_40_12
XFILLER_51_617 vccd1 vssd1 vccd1 vssd1 X2_sky130_fd_sc_hd__fill_1
XFILLER_91_3 vssd1 vccd1 vssd1 vccd1 X2_sky130_ef_sc_hd__decap_40_12
XFILLER_31_374 vssd1 vccd1 vssd1 vccd1 X2_sky130_ef_sc_hd__decap_40_12
XFILLER_8_581 vssd1 vccd1 vccd1 vssd1 X2_sky130_fd_sc_hd__fill_4
XFILLER_98_341 vssd1 vccd1 vccd1 vssd1 X2_sky130_fd_sc_hd__fill_2
XFILLER_98_363 vccd1 vssd1 vccd1 vssd1 X2_sky130_fd_sc_hd__fill_1
XFILLER_98_385 vssd1 vccd1 vccd1 vssd1 X2_sky130_fd_sc_hd__fill_2
XFILLER_100_313 vssd1 vccd1 vccd1 vssd1 X2_sky130_fd_sc_hd__fill_2
XFILLER_86_525 vssd1 vccd1 vccd1 vssd1 X2_sky130_fd_sc_hd__fill_4
XFILLER_58_249 vssd1 vccd1 vccd1 vssd1 X2_sky130_fd_sc_hd__fill_2
XFILLER_39_441 vssd1 vccd1 vccd1 vssd1 X2_sky130_fd_sc_hd__fill_4
XFILLER_86_569 vssd1 vccd1 vssd1 vccd1 X2_sky130_ef_sc_hd__decap_40_12
XTAP_TAPCELL_ROW_1_234 vccd1 vssd1 X2_sky130_fd_sc_hd__tapvpwrvgnd_1
XFILLER_39_485 vssd1 vccd1 vssd1 vccd1 X2_sky130_ef_sc_hd__decap_40_12
XTAP_TAPCELL_ROW_37_631 vccd1 vssd1 X2_sky130_fd_sc_hd__tapvpwrvgnd_1
XTAP_TAPCELL_ROW_65_940 vccd1 vssd1 X2_sky130_fd_sc_hd__tapvpwrvgnd_1
XFILLER_41_105 vssd1 vccd1 vccd1 vssd1 X2_sky130_fd_sc_hd__fill_4
XFILLER_54_477 vccd1 vssd1 vccd1 vssd1 X2_sky130_fd_sc_hd__fill_1
XFILLER_25_69 vssd1 vccd1 vssd1 vccd1 X2_sky130_ef_sc_hd__decap_40_12
XFILLER_41_149 vssd1 vccd1 vssd1 vccd1 X2_sky130_ef_sc_hd__decap_40_12
XFILLER_10_525 vssd1 vccd1 vccd1 vssd1 X2_sky130_fd_sc_hd__fill_4
XFILLER_22_363 vccd1 vssd1 vccd1 vssd1 X2_sky130_fd_sc_hd__fill_1
XFILLER_10_569 vssd1 vccd1 vssd1 vccd1 X2_sky130_ef_sc_hd__decap_40_12
XFILLER_41_57 vssd1 vccd1 vssd1 vccd1 X2_sky130_ef_sc_hd__decap_40_12
XFILLER_6_529 vssd1 vccd1 vccd1 vssd1 X2_sky130_fd_sc_hd__fill_2
XTAP_TAPCELL_ROW_9_323 vccd1 vssd1 X2_sky130_fd_sc_hd__tapvpwrvgnd_1
XANTENNA__556__CLK _601_/CLK vssd1 vccd1 vccd1 vssd1 X2_sky130_fd_sc_hd__diode_2
XFILLER_1_223 vccd1 vssd1 vccd1 vssd1 X2_sky130_fd_sc_hd__fill_1
XFILLER_77_503 vccd1 vssd1 vccd1 vssd1 X2_sky130_fd_sc_hd__fill_1
XFILLER_49_205 vssd1 vccd1 vccd1 vssd1 X2_sky130_fd_sc_hd__fill_8
XFILLER_2_29 vssd1 vccd1 vssd1 vccd1 X2_sky130_ef_sc_hd__decap_40_12
XFILLER_89_385 vssd1 vccd1 vccd1 vssd1 X2_sky130_fd_sc_hd__fill_4
XFILLER_49_249 vssd1 vccd1 vssd1 vccd1 X2_sky130_ef_sc_hd__decap_40_12
XFILLER_66_65 vssd1 vccd1 vssd1 vccd1 X2_sky130_ef_sc_hd__decap_40_12
XFILLER_17_113 vssd1 vccd1 vssd1 vccd1 X2_sky130_ef_sc_hd__decap_40_12
XANTENNA_input11_A adc_data_in[8] vssd1 vccd1 vccd1 vssd1 X2_sky130_fd_sc_hd__diode_2
XFILLER_33_617 vccd1 vssd1 vccd1 vssd1 X2_sky130_fd_sc_hd__fill_1
X_524_ vccd1 vssd1 vccd1 vssd1 _524_/Y _525_/A X2_sky130_fd_sc_hd__inv_2
X_455_ vccd1 vssd1 vccd1 vssd1 _455_/Y _473_/A X2_sky130_fd_sc_hd__inv_2
XFILLER_82_53 vssd1 vccd1 vssd1 vccd1 X2_sky130_ef_sc_hd__decap_40_12
XFILLER_82_97 vssd1 vccd1 vssd1 vccd1 X2_sky130_ef_sc_hd__decap_40_12
XFILLER_60_469 vssd1 vccd1 vccd1 vssd1 X2_sky130_fd_sc_hd__fill_4
XFILLER_13_385 vssd1 vccd1 vccd1 vssd1 X2_sky130_fd_sc_hd__fill_4
XTAP_TAPCELL_ROW_71_998 vccd1 vssd1 X2_sky130_fd_sc_hd__tapvpwrvgnd_1
X_386_ vccd1 vssd1 vssd1 vccd1 _413_/A _392_/A _386_/B X2_sky130_fd_sc_hd__nand2_1
XTAP_TAPCELL_ROW_43_689 vccd1 vssd1 X2_sky130_fd_sc_hd__tapvpwrvgnd_1
XFILLER_9_389 vssd1 vccd1 vccd1 vssd1 X2_sky130_fd_sc_hd__fill_2
XANTENNA__290__X _291_/B vssd1 vccd1 vccd1 vssd1 X2_sky130_fd_sc_hd__diode_2
XFILLER_5_573 vssd1 vccd1 vssd1 vccd1 X2_sky130_ef_sc_hd__decap_40_12
XFILLER_99_105 vssd1 vccd1 vccd1 vssd1 X2_sky130_fd_sc_hd__fill_4
XFILLER_99_149 vssd1 vccd1 vssd1 vccd1 X2_sky130_ef_sc_hd__decap_40_12
XFILLER_68_525 vssd1 vccd1 vccd1 vssd1 X2_sky130_fd_sc_hd__fill_4
XFILLER_95_366 vssd1 vccd1 vccd1 vssd1 X2_sky130_fd_sc_hd__fill_8
XFILLER_68_569 vssd1 vccd1 vccd1 vssd1 X2_sky130_fd_sc_hd__fill_4
XFILLER_83_517 vssd1 vccd1 vssd1 vccd1 X2_sky130_ef_sc_hd__decap_40_12
XFILLER_36_477 vccd1 vssd1 vccd1 vssd1 X2_sky130_fd_sc_hd__fill_1
XFILLER_91_561 vssd1 vccd1 vssd1 vccd1 X2_sky130_ef_sc_hd__decap_40_12
XFILLER_23_105 vssd1 vccd1 vccd1 vssd1 X2_sky130_fd_sc_hd__fill_4
XFILLER_51_447 vccd1 vssd1 vccd1 vssd1 X2_sky130_fd_sc_hd__fill_1
XFILLER_23_149 vssd1 vccd1 vssd1 vccd1 X2_sky130_ef_sc_hd__decap_40_12
XFILLER_31_193 vssd1 vccd1 vssd1 vccd1 X2_sky130_ef_sc_hd__decap_40_12
XFILLER_11_27 vssd1 vccd1 vssd1 vccd1 X2_sky130_ef_sc_hd__decap_40_12
XFILLER_59_503 vccd1 vssd1 vccd1 vssd1 X2_sky130_fd_sc_hd__fill_1
XANTENNA_input3_A adc_data_in[11] vssd1 vccd1 vccd1 vssd1 X2_sky130_fd_sc_hd__diode_2
XFILLER_98_193 vssd1 vccd1 vccd1 vssd1 X2_sky130_fd_sc_hd__fill_2
XFILLER_100_121 vssd1 vccd1 vssd1 vccd1 X2_sky130_ef_sc_hd__decap_40_12
XFILLER_86_333 vssd1 vccd1 vssd1 vccd1 X2_sky130_ef_sc_hd__decap_40_12
XFILLER_100_165 vssd1 vccd1 vssd1 vccd1 X2_sky130_ef_sc_hd__decap_40_12
XFILLER_86_377 vssd1 vccd1 vssd1 vccd1 X2_sky130_ef_sc_hd__decap_40_12
XFILLER_15_617 vssd1 vccd1 vccd1 vssd1 X2_sky130_fd_sc_hd__fill_8
XFILLER_42_403 vssd1 vccd1 vccd1 vssd1 X2_sky130_fd_sc_hd__fill_2
XFILLER_42_469 vssd1 vccd1 vccd1 vssd1 X2_sky130_fd_sc_hd__fill_4
XFILLER_10_333 vssd1 vccd1 vssd1 vccd1 X2_sky130_ef_sc_hd__decap_40_12
XFILLER_22_193 vssd1 vccd1 vccd1 vssd1 X2_sky130_fd_sc_hd__fill_2
XTAP_TAPCELL_ROW_40_659 vccd1 vssd1 X2_sky130_fd_sc_hd__tapvpwrvgnd_1
XFILLER_10_377 vssd1 vccd1 vssd1 vccd1 X2_sky130_ef_sc_hd__decap_40_12
XTAP_TAPCELL_ROW_75_1046 vccd1 vssd1 X2_sky130_fd_sc_hd__tapvpwrvgnd_1
XFILLER_97_609 vssd1 vccd1 vccd1 vssd1 X2_sky130_fd_sc_hd__fill_4
XFILLER_2_587 vccd1 vssd1 vccd1 vssd1 X2_sky130_fd_sc_hd__fill_1
XFILLER_89_193 vssd1 vccd1 vssd1 vccd1 X2_sky130_ef_sc_hd__decap_40_12
XFILLER_77_333 vssd1 vccd1 vccd1 vssd1 X2_sky130_fd_sc_hd__fill_2
XFILLER_65_517 vssd1 vccd1 vssd1 vccd1 X2_sky130_ef_sc_hd__decap_40_12
XFILLER_18_433 vssd1 vccd1 vssd1 vccd1 X2_sky130_ef_sc_hd__decap_40_12
XFILLER_58_580 vssd1 vccd1 vccd1 vssd1 X2_sky130_fd_sc_hd__fill_2
XTAP_TAPCELL_ROW_48_748 vccd1 vssd1 X2_sky130_fd_sc_hd__tapvpwrvgnd_1
XFILLER_18_477 vssd1 vccd1 vssd1 vccd1 X2_sky130_ef_sc_hd__decap_40_12
XTAP_TAPCELL_ROW_86_1164 vccd1 vssd1 X2_sky130_fd_sc_hd__tapvpwrvgnd_1
XFILLER_73_561 vssd1 vccd1 vssd1 vccd1 X2_sky130_ef_sc_hd__decap_40_12
XFILLER_21_609 vssd1 vccd1 vccd1 vssd1 X2_sky130_fd_sc_hd__fill_4
XFILLER_33_447 vccd1 vssd1 vccd1 vssd1 X2_sky130_fd_sc_hd__fill_1
X_507_ vccd1 vssd1 vccd1 vssd1 _507_/Y _517_/A X2_sky130_fd_sc_hd__inv_2
XFILLER_60_233 vccd1 vssd1 vccd1 vssd1 X2_sky130_fd_sc_hd__fill_1
XFILLER_60_277 vssd1 vccd1 vssd1 vccd1 X2_sky130_ef_sc_hd__decap_40_12
X_438_ vccd1 vssd1 vccd1 vssd1 _436_/B _436_/A _434_/A _438_/Y X2_sky130_fd_sc_hd__a21oi_1
XFILLER_13_193 vssd1 vccd1 vssd1 vccd1 X2_sky130_ef_sc_hd__decap_40_12
X_369_ vccd1 vssd1 vssd1 vccd1 hold5/A _545_/Q _373_/B X2_sky130_fd_sc_hd__nand2b_1
XANTENNA__461__A _521_/A vssd1 vccd1 vccd1 vssd1 X2_sky130_fd_sc_hd__diode_2
XTAP_TAPCELL_ROW_97_1282 vccd1 vssd1 X2_sky130_fd_sc_hd__tapvpwrvgnd_1
XFILLER_54_3 vssd1 vccd1 vssd1 vccd1 X2_sky130_ef_sc_hd__decap_40_12
XFILLER_68_355 vssd1 vccd1 vccd1 vssd1 X2_sky130_fd_sc_hd__fill_8
XFILLER_68_377 vssd1 vccd1 vssd1 vccd1 X2_sky130_ef_sc_hd__decap_40_12
XFILLER_64_561 vssd1 vccd1 vccd1 vssd1 X2_sky130_fd_sc_hd__fill_2
XFILLER_64_583 vssd1 vccd1 vccd1 vssd1 X2_sky130_fd_sc_hd__fill_2
XFILLER_24_469 vssd1 vccd1 vccd1 vssd1 X2_sky130_fd_sc_hd__fill_4
XFILLER_51_244 vssd1 vccd1 vssd1 vccd1 X2_sky130_ef_sc_hd__decap_40_12
XFILLER_22_15 vssd1 vccd1 vssd1 vccd1 X2_sky130_ef_sc_hd__decap_40_12
XFILLER_3_329 vssd1 vccd1 vccd1 vssd1 X2_sky130_fd_sc_hd__fill_4
XFILLER_79_609 vssd1 vccd1 vccd1 vssd1 X2_sky130_fd_sc_hd__fill_4
XFILLER_86_141 vssd1 vccd1 vssd1 vccd1 X2_sky130_ef_sc_hd__decap_40_12
XFILLER_47_23 vssd1 vccd1 vssd1 vccd1 X2_sky130_ef_sc_hd__decap_40_12
XANTENNA_fanout61_A _521_/A vssd1 vccd1 vccd1 vssd1 X2_sky130_fd_sc_hd__diode_2
XTAP_TAPCELL_ROW_17_409 vccd1 vssd1 X2_sky130_fd_sc_hd__tapvpwrvgnd_1
XFILLER_55_561 vssd1 vccd1 vccd1 vssd1 X2_sky130_fd_sc_hd__fill_2
XTAP_TAPCELL_ROW_45_718 vccd1 vssd1 X2_sky130_fd_sc_hd__tapvpwrvgnd_1
XFILLER_15_447 vccd1 vssd1 vccd1 vssd1 X2_sky130_fd_sc_hd__fill_1
XFILLER_70_531 vccd1 vssd1 vccd1 vssd1 X2_sky130_fd_sc_hd__fill_1
XFILLER_63_55 vccd1 vssd1 vccd1 vssd1 X2_sky130_fd_sc_hd__fill_1
XFILLER_30_417 vssd1 vccd1 vccd1 vssd1 X2_sky130_fd_sc_hd__fill_2
XFILLER_42_277 vssd1 vccd1 vssd1 vccd1 X2_sky130_ef_sc_hd__decap_40_12
XTAP_TAPCELL_ROW_25_497 vccd1 vssd1 X2_sky130_fd_sc_hd__tapvpwrvgnd_1
XFILLER_7_613 vssd1 vccd1 vccd1 vssd1 X2_sky130_fd_sc_hd__fill_2
XFILLER_10_141 vssd1 vccd1 vssd1 vccd1 X2_sky130_ef_sc_hd__decap_40_12
XFILLER_12_81 vssd1 vccd1 vccd1 vssd1 X2_sky130_fd_sc_hd__fill_2
XFILLER_6_189 vssd1 vccd1 vccd1 vssd1 X2_sky130_fd_sc_hd__fill_4
XFILLER_88_41 vssd1 vccd1 vssd1 vccd1 X2_sky130_ef_sc_hd__decap_40_12
XFILLER_88_85 vssd1 vccd1 vssd1 vccd1 X2_sky130_ef_sc_hd__decap_40_12
Xtop_soc_76 wbs_dat_o[24] top_soc_76/HI vccd1 vssd1 vssd1 vccd1 X2_sky130_fd_sc_hd__conb_1
XFILLER_92_133 vssd1 vccd1 vccd1 vssd1 X2_sky130_fd_sc_hd__fill_4
XFILLER_65_358 vssd1 vccd1 vssd1 vccd1 X2_sky130_ef_sc_hd__decap_40_12
XFILLER_46_550 vssd1 vccd1 vccd1 vssd1 X2_sky130_fd_sc_hd__fill_2
XFILLER_92_177 vssd1 vccd1 vssd1 vccd1 X2_sky130_ef_sc_hd__decap_40_12
XFILLER_46_572 vssd1 vccd1 vssd1 vccd1 X2_sky130_ef_sc_hd__decap_40_12
XANTENNA__456__A _473_/A vssd1 vccd1 vccd1 vssd1 X2_sky130_fd_sc_hd__diode_2
XFILLER_73_391 vccd1 vssd1 vccd1 vssd1 X2_sky130_fd_sc_hd__fill_1
XFILLER_61_553 vssd1 vccd1 vccd1 vssd1 X2_sky130_fd_sc_hd__fill_4
XFILLER_21_417 vssd1 vccd1 vssd1 vccd1 X2_sky130_ef_sc_hd__decap_40_12
XFILLER_33_299 vssd1 vccd1 vssd1 vccd1 X2_sky130_ef_sc_hd__decap_40_12
XTAP_TAPCELL_ROW_99_1311 vccd1 vssd1 X2_sky130_fd_sc_hd__tapvpwrvgnd_1
XFILLER_29_517 vssd1 vccd1 vssd1 vccd1 X2_sky130_ef_sc_hd__decap_40_12
XFILLER_84_601 vssd1 vccd1 vssd1 vccd1 X2_sky130_ef_sc_hd__decap_40_12
XFILLER_68_141 vssd1 vccd1 vssd1 vccd1 X2_sky130_ef_sc_hd__decap_40_12
XFILLER_83_111 vccd1 vssd1 vccd1 vssd1 X2_sky130_fd_sc_hd__fill_1
XFILLER_17_15 vssd1 vccd1 vssd1 vccd1 X2_sky130_ef_sc_hd__decap_40_12
XFILLER_37_561 vccd1 vssd1 vccd1 vssd1 X2_sky130_fd_sc_hd__fill_1
XFILLER_71_317 vssd1 vccd1 vssd1 vccd1 X2_sky130_ef_sc_hd__decap_40_12
XFILLER_24_233 vssd1 vccd1 vssd1 vccd1 X2_sky130_ef_sc_hd__decap_40_12
XFILLER_52_553 vssd1 vccd1 vccd1 vssd1 X2_sky130_fd_sc_hd__fill_2
XFILLER_12_417 vssd1 vccd1 vccd1 vssd1 X2_sky130_fd_sc_hd__fill_2
XFILLER_24_277 vssd1 vccd1 vssd1 vccd1 X2_sky130_ef_sc_hd__decap_40_12
XFILLER_52_586 vssd1 vccd1 vccd1 vssd1 X2_sky130_fd_sc_hd__fill_2
XTAP_TAPCELL_ROW_22_467 vccd1 vssd1 X2_sky130_fd_sc_hd__tapvpwrvgnd_1
XFILLER_33_69 vssd1 vccd1 vssd1 vccd1 X2_sky130_ef_sc_hd__decap_40_12
XTAP_TAPCELL_ROW_50_765 vccd1 vssd1 X2_sky130_fd_sc_hd__tapvpwrvgnd_1
XFILLER_3_137 vssd1 vccd1 vssd1 vccd1 X2_sky130_ef_sc_hd__decap_40_12
XTAP_TAPCELL_ROW_72_1016 vccd1 vssd1 X2_sky130_fd_sc_hd__tapvpwrvgnd_1
XFILLER_79_417 vssd1 vccd1 vssd1 vccd1 X2_sky130_ef_sc_hd__decap_40_12
XFILLER_87_461 vssd1 vccd1 vssd1 vccd1 X2_sky130_ef_sc_hd__decap_40_12
XFILLER_75_601 vssd1 vccd1 vssd1 vccd1 X2_sky130_ef_sc_hd__decap_40_12
XFILLER_58_77 vssd1 vccd1 vccd1 vssd1 X2_sky130_fd_sc_hd__fill_4
XANTENNA_fanout64_X _527_/A vssd1 vccd1 vccd1 vssd1 X2_sky130_fd_sc_hd__diode_2
XFILLER_101_293 vssd1 vccd1 vccd1 vssd1 X2_sky130_fd_sc_hd__fill_4
XFILLER_74_133 vssd1 vccd1 vccd1 vssd1 X2_sky130_fd_sc_hd__fill_4
XTAP_TAPCELL_ROW_58_854 vccd1 vssd1 X2_sky130_fd_sc_hd__tapvpwrvgnd_1
XFILLER_74_177 vssd1 vccd1 vssd1 vccd1 X2_sky130_ef_sc_hd__decap_40_12
XFILLER_74_65 vssd1 vccd1 vssd1 vccd1 X2_sky130_ef_sc_hd__decap_40_12
XTAP_TAPCELL_ROW_83_1134 vccd1 vssd1 X2_sky130_fd_sc_hd__tapvpwrvgnd_1
XFILLER_55_391 vccd1 vssd1 vccd1 vssd1 X2_sky130_fd_sc_hd__fill_1
XFILLER_15_277 vssd1 vccd1 vccd1 vssd1 X2_sky130_fd_sc_hd__fill_2
XFILLER_70_361 vssd1 vccd1 vccd1 vssd1 X2_sky130_fd_sc_hd__fill_2
XFILLER_90_53 vssd1 vccd1 vssd1 vccd1 X2_sky130_ef_sc_hd__decap_40_12
XFILLER_90_97 vssd1 vccd1 vssd1 vccd1 X2_sky130_ef_sc_hd__decap_40_12
XFILLER_11_461 vssd1 vccd1 vssd1 vccd1 X2_sky130_ef_sc_hd__decap_40_12
XFILLER_99_51 vssd1 vccd1 vccd1 vssd1 X2_sky130_fd_sc_hd__fill_4
XTAP_TAPCELL_ROW_94_1252 vccd1 vssd1 X2_sky130_fd_sc_hd__tapvpwrvgnd_1
XFILLER_97_225 vssd1 vccd1 vssd1 vccd1 X2_sky130_ef_sc_hd__decap_40_12
XFILLER_66_601 vccd1 vssd1 vccd1 vssd1 X2_sky130_fd_sc_hd__fill_1
XFILLER_17_3 vssd1 vccd1 vssd1 vccd1 X2_sky130_ef_sc_hd__decap_40_12
XFILLER_65_111 vccd1 vssd1 vccd1 vssd1 X2_sky130_fd_sc_hd__fill_1
XFILLER_81_615 vccd1 vssd1 vccd1 vssd1 X2_sky130_fd_sc_hd__fill_1
XFILLER_19_561 vssd1 vccd1 vssd1 vccd1 X2_sky130_ef_sc_hd__decap_40_12
XFILLER_93_497 vssd1 vccd1 vccd1 vssd1 X2_sky130_fd_sc_hd__fill_4
XFILLER_53_317 vssd1 vccd1 vssd1 vccd1 X2_sky130_ef_sc_hd__decap_40_12
XFILLER_34_531 vccd1 vssd1 vccd1 vssd1 X2_sky130_fd_sc_hd__fill_1
XFILLER_21_225 vssd1 vccd1 vssd1 vccd1 X2_sky130_ef_sc_hd__decap_40_12
XFILLER_9_93 vssd1 vccd1 vssd1 vccd1 X2_sky130_ef_sc_hd__decap_40_12
XFILLER_69_461 vssd1 vccd1 vssd1 vccd1 X2_sky130_ef_sc_hd__decap_40_12
XFILLER_56_133 vssd1 vccd1 vccd1 vssd1 X2_sky130_fd_sc_hd__fill_4
XTAP_TAPCELL_ROW_27_515 vccd1 vssd1 X2_sky130_fd_sc_hd__tapvpwrvgnd_1
XFILLER_84_475 vccd1 vssd1 vccd1 vssd1 X2_sky130_fd_sc_hd__fill_1
XFILLER_56_177 vssd1 vccd1 vssd1 vccd1 X2_sky130_ef_sc_hd__decap_40_12
XTAP_TAPCELL_ROW_55_824 vccd1 vssd1 X2_sky130_fd_sc_hd__tapvpwrvgnd_1
XFILLER_37_391 vccd1 vssd1 vccd1 vssd1 X2_sky130_fd_sc_hd__fill_1
XFILLER_71_125 vssd1 vccd1 vssd1 vccd1 X2_sky130_ef_sc_hd__decap_40_12
XFILLER_25_553 vssd1 vccd1 vccd1 vssd1 X2_sky130_fd_sc_hd__fill_4
XFILLER_40_501 vssd1 vccd1 vssd1 vccd1 X2_sky130_ef_sc_hd__decap_40_12
XFILLER_71_169 vssd1 vccd1 vssd1 vccd1 X2_sky130_ef_sc_hd__decap_40_12
XFILLER_25_597 vssd1 vccd1 vssd1 vccd1 X2_sky130_ef_sc_hd__decap_40_12
XFILLER_52_372 vssd1 vccd1 vccd1 vssd1 X2_sky130_fd_sc_hd__fill_8
XFILLER_100_41 vssd1 vccd1 vssd1 vccd1 X2_sky130_ef_sc_hd__decap_40_12
XFILLER_40_589 vssd1 vccd1 vssd1 vccd1 X2_sky130_ef_sc_hd__decap_40_12
XFILLER_100_85 vssd1 vccd1 vssd1 vccd1 X2_sky130_ef_sc_hd__decap_40_12
XFILLER_4_413 vssd1 vccd1 vccd1 vssd1 X2_sky130_fd_sc_hd__fill_4
XFILLER_4_457 vssd1 vccd1 vssd1 vccd1 X2_sky130_ef_sc_hd__decap_40_12
XFILLER_79_225 vssd1 vccd1 vssd1 vccd1 X2_sky130_ef_sc_hd__decap_40_12
XFILLER_48_601 vssd1 vccd1 vssd1 vccd1 X2_sky130_ef_sc_hd__decap_40_12
XTAP_TAPCELL_ROW_7_295 vccd1 vssd1 X2_sky130_fd_sc_hd__tapvpwrvgnd_1
XFILLER_47_111 vccd1 vssd1 vccd1 vssd1 X2_sky130_fd_sc_hd__fill_1
XFILLER_90_401 vssd1 vccd1 vssd1 vccd1 X2_sky130_ef_sc_hd__decap_40_12
XFILLER_75_497 vssd1 vccd1 vccd1 vssd1 X2_sky130_fd_sc_hd__fill_4
XFILLER_63_615 vccd1 vssd1 vccd1 vssd1 X2_sky130_fd_sc_hd__fill_1
XFILLER_16_531 vccd1 vssd1 vccd1 vssd1 X2_sky130_fd_sc_hd__fill_1
XFILLER_90_445 vssd1 vccd1 vssd1 vccd1 X2_sky130_ef_sc_hd__decap_40_12
XFILLER_31_501 vssd1 vccd1 vccd1 vssd1 X2_sky130_fd_sc_hd__fill_2
XFILLER_90_489 vssd1 vccd1 vssd1 vccd1 X2_sky130_ef_sc_hd__decap_40_12
XFILLER_50_309 vssd1 vccd1 vccd1 vssd1 X2_sky130_fd_sc_hd__fill_4
XFILLER_7_273 vssd1 vccd1 vccd1 vssd1 X2_sky130_fd_sc_hd__fill_4
XFILLER_98_501 vssd1 vccd1 vssd1 vccd1 X2_sky130_ef_sc_hd__decap_40_12
XFILLER_98_545 vssd1 vccd1 vssd1 vccd1 X2_sky130_ef_sc_hd__decap_40_12
XFILLER_98_589 vssd1 vccd1 vssd1 vccd1 X2_sky130_ef_sc_hd__decap_40_12
XFILLER_85_217 vssd1 vccd1 vccd1 vssd1 X2_sky130_fd_sc_hd__fill_4
XFILLER_38_133 vssd1 vccd1 vccd1 vssd1 X2_sky130_fd_sc_hd__fill_4
XFILLER_66_475 vccd1 vssd1 vccd1 vssd1 X2_sky130_fd_sc_hd__fill_1
XFILLER_19_391 vccd1 vssd1 vccd1 vssd1 X2_sky130_fd_sc_hd__fill_1
XFILLER_81_445 vssd1 vccd1 vccd1 vssd1 X2_sky130_fd_sc_hd__fill_2
XFILLER_53_125 vssd1 vccd1 vssd1 vccd1 X2_sky130_ef_sc_hd__decap_40_12
XFILLER_22_501 vssd1 vccd1 vssd1 vccd1 X2_sky130_ef_sc_hd__decap_40_12
XFILLER_34_350 vssd1 vccd1 vccd1 vssd1 X2_sky130_fd_sc_hd__fill_2
XFILLER_53_169 vssd1 vccd1 vssd1 vccd1 X2_sky130_ef_sc_hd__decap_40_12
XFILLER_14_27 vccd1 vssd1 vccd1 vssd1 X2_sky130_fd_sc_hd__fill_1
XTAP_TAPCELL_ROW_101_1329 vccd1 vssd1 X2_sky130_fd_sc_hd__tapvpwrvgnd_1
XFILLER_22_545 vssd1 vccd1 vssd1 vccd1 X2_sky130_ef_sc_hd__decap_40_12
XFILLER_22_589 vssd1 vccd1 vssd1 vccd1 X2_sky130_ef_sc_hd__decap_40_12
XTAP_TAPCELL_ROW_32_573 vccd1 vssd1 X2_sky130_fd_sc_hd__tapvpwrvgnd_1
XTAP_TAPCELL_ROW_60_882 vccd1 vssd1 X2_sky130_fd_sc_hd__tapvpwrvgnd_1
XANTENNA__363__B _534_/Q vssd1 vccd1 vccd1 vssd1 X2_sky130_fd_sc_hd__diode_2
XFILLER_30_15 vssd1 vccd1 vssd1 vccd1 X2_sky130_ef_sc_hd__decap_40_12
XFILLER_1_405 vssd1 vccd1 vssd1 vccd1 X2_sky130_ef_sc_hd__decap_40_12
XFILLER_89_501 vssd1 vccd1 vccd1 vssd1 X2_sky130_fd_sc_hd__fill_2
XFILLER_1_449 vssd1 vccd1 vssd1 vccd1 X2_sky130_ef_sc_hd__decap_40_12
XFILLER_39_35 vssd1 vccd1 vssd1 vccd1 X2_sky130_ef_sc_hd__decap_40_12
XFILLER_39_57 vssd1 vccd1 vssd1 vccd1 X2_sky130_ef_sc_hd__decap_40_12
XFILLER_29_111 vccd1 vssd1 vccd1 vssd1 X2_sky130_fd_sc_hd__fill_1
XTAP_TAPCELL_ROW_4_265 vccd1 vssd1 X2_sky130_fd_sc_hd__tapvpwrvgnd_1
XFILLER_17_317 vssd1 vccd1 vssd1 vccd1 X2_sky130_ef_sc_hd__decap_40_12
XFILLER_72_401 vssd1 vccd1 vssd1 vccd1 X2_sky130_ef_sc_hd__decap_40_12
XTAP_TAPCELL_ROW_68_971 vccd1 vssd1 X2_sky130_fd_sc_hd__tapvpwrvgnd_1
X_540_ vssd1 vccd1 vccd1 vssd1 _553_/CLK _540_/D _460_/Y _540_/Q X2_sky130_fd_sc_hd__dfrtp_4
XFILLER_57_497 vssd1 vccd1 vccd1 vssd1 X2_sky130_fd_sc_hd__fill_4
XFILLER_45_615 vccd1 vssd1 vccd1 vssd1 X2_sky130_fd_sc_hd__fill_1
XFILLER_72_445 vssd1 vccd1 vssd1 vccd1 X2_sky130_ef_sc_hd__decap_40_12
XFILLER_13_501 vssd1 vccd1 vccd1 vssd1 X2_sky130_fd_sc_hd__fill_2
XFILLER_25_361 vssd1 vccd1 vssd1 vccd1 X2_sky130_ef_sc_hd__decap_40_12
XFILLER_32_309 vssd1 vccd1 vssd1 vccd1 X2_sky130_ef_sc_hd__decap_40_12
XFILLER_72_489 vssd1 vccd1 vssd1 vccd1 X2_sky130_ef_sc_hd__decap_40_12
X_471_ vccd1 vssd1 vccd1 vssd1 _471_/Y _473_/A X2_sky130_fd_sc_hd__inv_2
XTAP_TAPCELL_ROW_80_1104 vccd1 vssd1 X2_sky130_fd_sc_hd__tapvpwrvgnd_1
XFILLER_9_505 vssd1 vccd1 vssd1 vccd1 X2_sky130_ef_sc_hd__decap_40_12
XFILLER_40_342 vccd1 vssd1 vccd1 vssd1 X2_sky130_fd_sc_hd__fill_1
XFILLER_71_55 vccd1 vssd1 vccd1 vssd1 X2_sky130_fd_sc_hd__fill_1
XFILLER_40_386 vssd1 vccd1 vssd1 vccd1 X2_sky130_ef_sc_hd__decap_40_12
XFILLER_4_221 vssd1 vccd1 vssd1 vccd1 X2_sky130_ef_sc_hd__decap_40_12
XTAP_TAPCELL_ROW_78_1077 vccd1 vssd1 X2_sky130_fd_sc_hd__tapvpwrvgnd_1
XFILLER_4_265 vssd1 vccd1 vssd1 vccd1 X2_sky130_ef_sc_hd__decap_40_12
XTAP_TAPCELL_ROW_91_1222 vccd1 vssd1 X2_sky130_fd_sc_hd__tapvpwrvgnd_1
XFILLER_20_81 vssd1 vccd1 vccd1 vssd1 X2_sky130_fd_sc_hd__fill_2
XFILLER_96_41 vssd1 vccd1 vssd1 vccd1 X2_sky130_ef_sc_hd__decap_40_12
XFILLER_96_85 vssd1 vccd1 vssd1 vccd1 X2_sky130_ef_sc_hd__decap_40_12
XFILLER_67_217 vssd1 vccd1 vccd1 vssd1 X2_sky130_fd_sc_hd__fill_4
XFILLER_95_559 vccd1 vssd1 vccd1 vssd1 X2_sky130_fd_sc_hd__fill_1
XFILLER_82_209 vssd1 vccd1 vssd1 vccd1 X2_sky130_ef_sc_hd__decap_40_12
XFILLER_75_261 vssd1 vccd1 vssd1 vccd1 X2_sky130_ef_sc_hd__decap_40_12
XFILLER_48_475 vccd1 vssd1 vccd1 vssd1 X2_sky130_fd_sc_hd__fill_1
XFILLER_35_125 vssd1 vccd1 vssd1 vccd1 X2_sky130_ef_sc_hd__decap_40_12
XTAP_TAPCELL_ROW_89_1195 vccd1 vssd1 X2_sky130_fd_sc_hd__tapvpwrvgnd_1
XFILLER_63_445 vssd1 vccd1 vccd1 vssd1 X2_sky130_fd_sc_hd__fill_2
XFILLER_35_169 vssd1 vccd1 vssd1 vccd1 X2_sky130_ef_sc_hd__decap_40_12
XFILLER_90_253 vssd1 vccd1 vssd1 vccd1 X2_sky130_ef_sc_hd__decap_40_12
XFILLER_63_489 vssd1 vccd1 vssd1 vccd1 X2_sky130_ef_sc_hd__decap_40_12
XFILLER_16_361 vssd1 vccd1 vccd1 vssd1 X2_sky130_fd_sc_hd__fill_2
XFILLER_50_139 vccd1 vssd1 vccd1 vssd1 X2_sky130_fd_sc_hd__fill_1
XANTENNA__464__A _527_/A vssd1 vccd1 vccd1 vssd1 X2_sky130_fd_sc_hd__diode_2
XFILLER_31_386 vssd1 vccd1 vccd1 vssd1 X2_sky130_fd_sc_hd__fill_4
XFILLER_84_3 vssd1 vccd1 vssd1 vccd1 X2_sky130_ef_sc_hd__decap_40_12
XFILLER_6_83 vccd1 vssd1 vccd1 vssd1 X2_sky130_fd_sc_hd__fill_1
XFILLER_100_336 vssd1 vccd1 vccd1 vssd1 X2_sky130_fd_sc_hd__fill_2
XFILLER_27_615 vccd1 vssd1 vccd1 vssd1 X2_sky130_fd_sc_hd__fill_1
XFILLER_94_581 vssd1 vccd1 vccd1 vssd1 X2_sky130_fd_sc_hd__fill_4
XFILLER_54_401 vssd1 vccd1 vssd1 vccd1 X2_sky130_ef_sc_hd__decap_40_12
XTAP_TAPCELL_ROW_1_235 vccd1 vssd1 X2_sky130_fd_sc_hd__tapvpwrvgnd_1
XTAP_TAPCELL_ROW_37_632 vccd1 vssd1 X2_sky130_fd_sc_hd__tapvpwrvgnd_1
XFILLER_39_497 vssd1 vccd1 vccd1 vssd1 X2_sky130_fd_sc_hd__fill_4
XTAP_TAPCELL_ROW_65_930 vccd1 vssd1 X2_sky130_fd_sc_hd__tapvpwrvgnd_1
XFILLER_54_445 vssd1 vccd1 vssd1 vccd1 X2_sky130_ef_sc_hd__decap_40_12
XFILLER_14_309 vssd1 vccd1 vssd1 vccd1 X2_sky130_ef_sc_hd__decap_40_12
XFILLER_25_15 vssd1 vccd1 vssd1 vccd1 X2_sky130_ef_sc_hd__decap_40_12
XFILLER_42_607 vccd1 vssd1 vccd1 vssd1 X2_sky130_fd_sc_hd__fill_1
XFILLER_41_69 vssd1 vccd1 vssd1 vccd1 X2_sky130_ef_sc_hd__decap_40_12
XTAP_TAPCELL_ROW_9_324 vccd1 vssd1 X2_sky130_fd_sc_hd__tapvpwrvgnd_1
XFILLER_2_19 vssd1 vccd1 vccd1 vssd1 X2_sky130_fd_sc_hd__fill_8
XFILLER_77_559 vccd1 vssd1 vccd1 vssd1 X2_sky130_fd_sc_hd__fill_1
XFILLER_92_529 vssd1 vccd1 vccd1 vssd1 X2_sky130_fd_sc_hd__fill_2
XFILLER_66_77 vssd1 vccd1 vccd1 vssd1 X2_sky130_fd_sc_hd__fill_4
XFILLER_64_209 vssd1 vccd1 vssd1 vccd1 X2_sky130_ef_sc_hd__decap_40_12
XFILLER_57_261 vssd1 vccd1 vssd1 vccd1 X2_sky130_ef_sc_hd__decap_40_12
XFILLER_17_125 vssd1 vccd1 vssd1 vccd1 X2_sky130_ef_sc_hd__decap_40_12
XFILLER_17_169 vssd1 vccd1 vssd1 vccd1 X2_sky130_ef_sc_hd__decap_40_12
X_523_ vccd1 vssd1 vccd1 vssd1 _523_/Y _525_/A X2_sky130_fd_sc_hd__inv_2
XFILLER_72_253 vssd1 vccd1 vssd1 vccd1 X2_sky130_ef_sc_hd__decap_40_12
X_454_ vccd1 vssd1 vccd1 vssd1 _454_/Y _473_/A X2_sky130_fd_sc_hd__inv_2
XFILLER_82_65 vssd1 vccd1 vssd1 vccd1 X2_sky130_ef_sc_hd__decap_40_12
XFILLER_32_139 vccd1 vssd1 vccd1 vssd1 X2_sky130_fd_sc_hd__fill_1
XFILLER_15_81 vssd1 vccd1 vssd1 vccd1 X2_sky130_ef_sc_hd__decap_40_12
XTAP_TAPCELL_ROW_71_999 vccd1 vssd1 X2_sky130_fd_sc_hd__tapvpwrvgnd_1
X_385_ vccd1 vssd1 vccd1 vssd1 _393_/C _359_/Y _360_/X _386_/B X2_sky130_fd_sc_hd__a21o_1
XFILLER_9_335 vccd1 vssd1 vccd1 vssd1 X2_sky130_fd_sc_hd__fill_1
XFILLER_40_194 vssd1 vccd1 vccd1 vssd1 X2_sky130_fd_sc_hd__fill_2
XFILLER_5_541 vssd1 vccd1 vssd1 vccd1 X2_sky130_ef_sc_hd__decap_40_12
XFILLER_5_585 vssd1 vccd1 vssd1 vccd1 X2_sky130_ef_sc_hd__decap_40_12
XFILLER_0_290 vssd1 vccd1 vccd1 vssd1 X2_sky130_fd_sc_hd__fill_4
XANTENNA__459__A _521_/A vssd1 vccd1 vccd1 vssd1 X2_sky130_fd_sc_hd__diode_2
XFILLER_95_334 vssd1 vccd1 vccd1 vssd1 X2_sky130_fd_sc_hd__fill_2
XFILLER_83_529 vssd1 vccd1 vssd1 vccd1 X2_sky130_ef_sc_hd__decap_40_12
XFILLER_76_581 vssd1 vccd1 vccd1 vssd1 X2_sky130_fd_sc_hd__fill_4
XFILLER_91_573 vssd1 vccd1 vssd1 vccd1 X2_sky130_ef_sc_hd__decap_40_12
XTAP_TAPCELL_ROW_62_900 vccd1 vssd1 X2_sky130_fd_sc_hd__tapvpwrvgnd_1
XFILLER_31_161 vssd1 vccd1 vccd1 vssd1 X2_sky130_fd_sc_hd__fill_4
XTAP_TAPCELL_ROW_14_370 vccd1 vssd1 X2_sky130_fd_sc_hd__tapvpwrvgnd_1
XFILLER_11_39 vssd1 vccd1 vssd1 vccd1 X2_sky130_ef_sc_hd__decap_40_12
XFILLER_101_601 vssd1 vccd1 vssd1 vccd1 X2_sky130_ef_sc_hd__decap_40_12
XFILLER_86_301 vssd1 vccd1 vccd1 vssd1 X2_sky130_fd_sc_hd__fill_4
XFILLER_100_133 vssd1 vccd1 vccd1 vssd1 X2_sky130_fd_sc_hd__fill_4
XFILLER_86_345 vssd1 vccd1 vssd1 vccd1 X2_sky130_ef_sc_hd__decap_40_12
XFILLER_59_559 vccd1 vssd1 vccd1 vssd1 X2_sky130_fd_sc_hd__fill_1
XFILLER_39_261 vssd1 vccd1 vccd1 vssd1 X2_sky130_fd_sc_hd__fill_4
XFILLER_100_177 vssd1 vccd1 vssd1 vccd1 X2_sky130_ef_sc_hd__decap_40_12
XFILLER_86_389 vssd1 vccd1 vssd1 vccd1 X2_sky130_ef_sc_hd__decap_40_12
XFILLER_74_529 vssd1 vccd1 vccd1 vssd1 X2_sky130_fd_sc_hd__fill_2
XFILLER_54_220 vssd1 vccd1 vssd1 vccd1 X2_sky130_ef_sc_hd__decap_40_12
XFILLER_27_445 vssd1 vccd1 vccd1 vssd1 X2_sky130_fd_sc_hd__fill_2
XFILLER_54_253 vssd1 vccd1 vccd1 vssd1 X2_sky130_fd_sc_hd__fill_8
XANTENNA__432__A3 _553_/D vssd1 vccd1 vccd1 vssd1 X2_sky130_fd_sc_hd__diode_2
XFILLER_14_139 vccd1 vssd1 vccd1 vssd1 X2_sky130_fd_sc_hd__fill_1
XFILLER_42_448 vssd1 vccd1 vccd1 vssd1 X2_sky130_fd_sc_hd__fill_2
XFILLER_10_301 vssd1 vccd1 vccd1 vssd1 X2_sky130_fd_sc_hd__fill_4
XFILLER_6_305 vssd1 vccd1 vccd1 vssd1 X2_sky130_fd_sc_hd__fill_2
XFILLER_10_345 vssd1 vccd1 vssd1 vccd1 X2_sky130_ef_sc_hd__decap_40_12
XFILLER_10_389 vssd1 vccd1 vssd1 vccd1 X2_sky130_ef_sc_hd__decap_40_12
XFILLER_2_533 vssd1 vccd1 vssd1 vccd1 X2_sky130_ef_sc_hd__decap_40_12
XTAP_TAPCELL_ROW_75_1047 vccd1 vssd1 X2_sky130_fd_sc_hd__tapvpwrvgnd_1
XFILLER_96_109 vssd1 vccd1 vssd1 vccd1 X2_sky130_ef_sc_hd__decap_40_12
XFILLER_89_161 vssd1 vccd1 vccd1 vssd1 X2_sky130_fd_sc_hd__fill_4
XFILLER_18_401 vssd1 vccd1 vssd1 vccd1 X2_sky130_ef_sc_hd__decap_40_12
XFILLER_37_209 vssd1 vccd1 vccd1 vssd1 X2_sky130_fd_sc_hd__fill_8
XFILLER_77_389 vssd1 vccd1 vccd1 vssd1 X2_sky130_fd_sc_hd__fill_2
XFILLER_65_529 vssd1 vccd1 vssd1 vccd1 X2_sky130_ef_sc_hd__decap_40_12
XFILLER_58_592 vssd1 vccd1 vccd1 vssd1 X2_sky130_fd_sc_hd__fill_2
XTAP_TAPCELL_ROW_48_749 vccd1 vssd1 X2_sky130_fd_sc_hd__tapvpwrvgnd_1
XFILLER_18_445 vssd1 vccd1 vssd1 vccd1 X2_sky130_ef_sc_hd__decap_40_12
XFILLER_45_242 vccd1 vssd1 vccd1 vssd1 X2_sky130_fd_sc_hd__fill_1
XFILLER_18_489 vssd1 vccd1 vssd1 vccd1 X2_sky130_ef_sc_hd__decap_40_12
X_506_ vccd1 vssd1 vccd1 vssd1 _506_/Y _517_/A X2_sky130_fd_sc_hd__inv_2
XTAP_TAPCELL_ROW_86_1165 vccd1 vssd1 X2_sky130_fd_sc_hd__tapvpwrvgnd_1
XFILLER_73_584 vssd1 vccd1 vccd1 vssd1 X2_sky130_fd_sc_hd__fill_2
XFILLER_73_573 vssd1 vccd1 vccd1 vssd1 X2_sky130_fd_sc_hd__fill_8
XFILLER_20_109 vssd1 vccd1 vssd1 vccd1 X2_sky130_ef_sc_hd__decap_40_12
XFILLER_60_289 vssd1 vccd1 vssd1 vccd1 X2_sky130_ef_sc_hd__decap_40_12
X_437_ vccd1 vssd1 vccd1 vssd1 _436_/B _436_/A _434_/B _437_/Y X2_sky130_fd_sc_hd__a21oi_1
XFILLER_13_161 vssd1 vccd1 vccd1 vssd1 X2_sky130_fd_sc_hd__fill_4
X_368_ _373_/A _368_/C _368_/A _368_/B _368_/D vssd1 vccd1 vccd1 vssd1 X2_sky130_fd_sc_hd__and4_1
XFILLER_9_165 vssd1 vccd1 vccd1 vssd1 X2_sky130_fd_sc_hd__fill_2
XTAP_TAPCELL_ROW_11_340 vccd1 vssd1 X2_sky130_fd_sc_hd__tapvpwrvgnd_1
X_299_ vssd1 vccd1 vccd1 vssd1 _574_/D hold84/X _299_/S _301_/A0 X2_sky130_fd_sc_hd__mux2_1
XTAP_TAPCELL_ROW_97_1283 vccd1 vssd1 X2_sky130_fd_sc_hd__tapvpwrvgnd_1
XFILLER_5_393 vssd1 vccd1 vssd1 vccd1 X2_sky130_ef_sc_hd__decap_40_12
XFILLER_87_109 vssd1 vccd1 vccd1 vssd1 X2_sky130_fd_sc_hd__fill_2
XFILLER_47_3 vccd1 vssd1 vccd1 vssd1 X2_sky130_fd_sc_hd__fill_1
XFILLER_3_51 vssd1 vccd1 vccd1 vssd1 X2_sky130_fd_sc_hd__fill_4
XPHY_EDGE_ROW_79_Left_181 vccd1 vssd1 vccd1 vssd1 X2_sky130_fd_sc_hd__decap_3
XFILLER_68_323 vssd1 vccd1 vccd1 vssd1 X2_sky130_fd_sc_hd__fill_2
XFILLER_28_209 vssd1 vccd1 vssd1 vccd1 X2_sky130_ef_sc_hd__decap_40_12
XFILLER_68_389 vssd1 vccd1 vssd1 vccd1 X2_sky130_ef_sc_hd__decap_40_12
XFILLER_56_529 vssd1 vccd1 vccd1 vssd1 X2_sky130_fd_sc_hd__fill_2
XFILLER_83_337 vssd1 vccd1 vssd1 vccd1 X2_sky130_ef_sc_hd__decap_40_12
XFILLER_49_581 vssd1 vccd1 vccd1 vssd1 X2_sky130_fd_sc_hd__fill_4
XFILLER_36_253 vccd1 vssd1 vccd1 vssd1 X2_sky130_fd_sc_hd__fill_1
XFILLER_51_223 vccd1 vssd1 vccd1 vssd1 X2_sky130_fd_sc_hd__fill_1
XFILLER_11_109 vssd1 vccd1 vccd1 vssd1 X2_sky130_fd_sc_hd__fill_2
XFILLER_51_256 vssd1 vccd1 vssd1 vccd1 X2_sky130_ef_sc_hd__decap_40_12
XPHY_EDGE_ROW_88_Left_190 vccd1 vssd1 vccd1 vssd1 X2_sky130_fd_sc_hd__decap_3
XFILLER_22_27 vccd1 vssd1 vccd1 vssd1 X2_sky130_fd_sc_hd__fill_1
XANTENNA__335__C1 _303_/X vssd1 vccd1 vccd1 vssd1 X2_sky130_fd_sc_hd__diode_2
XFILLER_78_109 vssd1 vccd1 vssd1 vccd1 X2_sky130_ef_sc_hd__decap_40_12
XFILLER_59_334 vssd1 vccd1 vccd1 vssd1 X2_sky130_fd_sc_hd__fill_2
XFILLER_101_475 vccd1 vssd1 vccd1 vssd1 X2_sky130_fd_sc_hd__fill_1
XFILLER_86_153 vssd1 vccd1 vssd1 vccd1 X2_sky130_ef_sc_hd__decap_40_12
XFILLER_59_389 vssd1 vccd1 vccd1 vssd1 X2_sky130_fd_sc_hd__fill_2
XFILLER_47_35 vssd1 vccd1 vssd1 vccd1 X2_sky130_ef_sc_hd__decap_40_12
XPHY_EDGE_ROW_29_Right_29 vccd1 vssd1 vccd1 vssd1 X2_sky130_fd_sc_hd__decap_3
XFILLER_86_197 vssd1 vccd1 vssd1 vccd1 X2_sky130_ef_sc_hd__decap_40_12
XFILLER_47_57 vssd1 vccd1 vssd1 vccd1 X2_sky130_ef_sc_hd__decap_40_12
XTAP_TAPCELL_ROW_45_719 vccd1 vssd1 X2_sky130_fd_sc_hd__tapvpwrvgnd_1
XFILLER_42_201 vssd1 vccd1 vccd1 vssd1 X2_sky130_fd_sc_hd__fill_2
XFILLER_70_587 vccd1 vssd1 vccd1 vssd1 X2_sky130_fd_sc_hd__fill_1
XFILLER_8_29 vssd1 vccd1 vssd1 vccd1 X2_sky130_ef_sc_hd__decap_40_12
XTAP_TAPCELL_ROW_25_498 vccd1 vssd1 X2_sky130_fd_sc_hd__tapvpwrvgnd_1
XFILLER_42_289 vssd1 vccd1 vssd1 vccd1 X2_sky130_ef_sc_hd__decap_40_12
XPHY_EDGE_ROW_38_Right_38 vccd1 vssd1 vccd1 vssd1 X2_sky130_fd_sc_hd__decap_3
XFILLER_10_153 vssd1 vccd1 vssd1 vccd1 X2_sky130_ef_sc_hd__decap_40_12
XANTENNA__326__C1 _303_/X vssd1 vccd1 vccd1 vssd1 X2_sky130_fd_sc_hd__diode_2
XFILLER_10_197 vssd1 vccd1 vssd1 vccd1 X2_sky130_ef_sc_hd__decap_40_12
XFILLER_88_53 vssd1 vccd1 vssd1 vccd1 X2_sky130_ef_sc_hd__decap_40_12
XFILLER_2_363 vccd1 vssd1 vccd1 vssd1 X2_sky130_fd_sc_hd__fill_1
XFILLER_88_97 vssd1 vccd1 vssd1 vccd1 X2_sky130_ef_sc_hd__decap_40_12
XFILLER_69_109 vssd1 vccd1 vccd1 vssd1 X2_sky130_fd_sc_hd__fill_2
Xtop_soc_66 user_irq[1] top_soc_66/HI vccd1 vssd1 vssd1 vccd1 X2_sky130_fd_sc_hd__conb_1
Xtop_soc_77 wbs_dat_o[25] top_soc_77/HI vccd1 vssd1 vssd1 vccd1 X2_sky130_fd_sc_hd__conb_1
XFILLER_38_518 vssd1 vccd1 vssd1 vccd1 X2_sky130_ef_sc_hd__decap_40_12
XFILLER_93_613 vssd1 vccd1 vccd1 vssd1 X2_sky130_fd_sc_hd__fill_2
XPHY_EDGE_ROW_47_Right_47 vccd1 vssd1 vccd1 vssd1 X2_sky130_fd_sc_hd__decap_3
XANTENNA__569__CLK _607_/CLK vssd1 vccd1 vccd1 vssd1 X2_sky130_fd_sc_hd__diode_2
XFILLER_65_337 vccd1 vssd1 vccd1 vssd1 X2_sky130_fd_sc_hd__fill_1
XFILLER_80_307 vccd1 vssd1 vccd1 vssd1 X2_sky130_fd_sc_hd__fill_1
XFILLER_18_253 vssd1 vccd1 vssd1 vccd1 X2_sky130_ef_sc_hd__decap_40_12
XFILLER_33_201 vccd1 vssd1 vccd1 vssd1 X2_sky130_fd_sc_hd__fill_1
XFILLER_92_189 vssd1 vccd1 vccd1 vssd1 X2_sky130_fd_sc_hd__fill_4
XFILLER_46_584 vssd1 vccd1 vccd1 vssd1 X2_sky130_fd_sc_hd__fill_4
XFILLER_33_223 vccd1 vssd1 vccd1 vssd1 X2_sky130_fd_sc_hd__fill_1
XFILLER_33_278 vssd1 vccd1 vccd1 vssd1 X2_sky130_fd_sc_hd__fill_2
XFILLER_21_429 vssd1 vccd1 vssd1 vccd1 X2_sky130_ef_sc_hd__decap_40_12
XPHY_EDGE_ROW_56_Right_56 vccd1 vssd1 vccd1 vssd1 X2_sky130_fd_sc_hd__decap_3
XTAP_TAPCELL_ROW_99_1312 vccd1 vssd1 X2_sky130_fd_sc_hd__tapvpwrvgnd_1
XANTENNA__472__A _473_/A vssd1 vccd1 vccd1 vssd1 X2_sky130_fd_sc_hd__diode_2
XANTENNA__332__A2 _304_/A vssd1 vccd1 vccd1 vssd1 X2_sky130_fd_sc_hd__diode_2
XPHY_EDGE_ROW_65_Right_65 vccd1 vssd1 vccd1 vssd1 X2_sky130_fd_sc_hd__decap_3
XFILLER_96_473 vssd1 vccd1 vccd1 vssd1 X2_sky130_fd_sc_hd__fill_2
XFILLER_84_613 vssd1 vccd1 vssd1 vccd1 X2_sky130_ef_sc_hd__decap_40_12
XFILLER_68_153 vssd1 vccd1 vssd1 vccd1 X2_sky130_ef_sc_hd__decap_40_12
XFILLER_56_304 vssd1 vccd1 vccd1 vssd1 X2_sky130_fd_sc_hd__fill_4
XFILLER_29_529 vssd1 vccd1 vssd1 vccd1 X2_sky130_ef_sc_hd__decap_40_12
XFILLER_68_197 vssd1 vccd1 vssd1 vccd1 X2_sky130_ef_sc_hd__decap_40_12
XFILLER_17_27 vssd1 vccd1 vssd1 vccd1 X2_sky130_ef_sc_hd__decap_40_12
XFILLER_83_167 vccd1 vssd1 vccd1 vssd1 X2_sky130_fd_sc_hd__fill_1
XFILLER_71_329 vssd1 vccd1 vccd1 vssd1 X2_sky130_fd_sc_hd__fill_4
XFILLER_24_245 vssd1 vccd1 vccd1 vssd1 X2_sky130_fd_sc_hd__fill_4
XFILLER_64_381 vssd1 vccd1 vccd1 vssd1 X2_sky130_fd_sc_hd__fill_2
XFILLER_33_15 vssd1 vccd1 vssd1 vccd1 X2_sky130_ef_sc_hd__decap_40_12
XPHY_EDGE_ROW_74_Right_74 vccd1 vssd1 vccd1 vssd1 X2_sky130_fd_sc_hd__decap_3
XFILLER_24_289 vssd1 vccd1 vssd1 vccd1 X2_sky130_ef_sc_hd__decap_40_12
XTAP_TAPCELL_ROW_22_457 vccd1 vssd1 X2_sky130_fd_sc_hd__tapvpwrvgnd_1
XTAP_TAPCELL_ROW_50_766 vccd1 vssd1 X2_sky130_fd_sc_hd__tapvpwrvgnd_1
XFILLER_20_473 vssd1 vccd1 vccd1 vssd1 X2_sky130_fd_sc_hd__fill_2
XFILLER_3_105 vssd1 vccd1 vccd1 vssd1 X2_sky130_fd_sc_hd__fill_4
XANTENNA__323__A2 _304_/A vssd1 vccd1 vccd1 vssd1 X2_sky130_fd_sc_hd__diode_2
XFILLER_3_149 vssd1 vccd1 vssd1 vccd1 X2_sky130_ef_sc_hd__decap_40_12
XPHY_EDGE_ROW_83_Right_83 vccd1 vssd1 vccd1 vssd1 X2_sky130_fd_sc_hd__decap_3
XFILLER_79_429 vssd1 vccd1 vssd1 vccd1 X2_sky130_ef_sc_hd__decap_40_12
XTAP_TAPCELL_ROW_72_1017 vccd1 vssd1 X2_sky130_fd_sc_hd__tapvpwrvgnd_1
XFILLER_87_473 vssd1 vccd1 vssd1 vccd1 X2_sky130_ef_sc_hd__decap_40_12
XFILLER_101_272 vssd1 vccd1 vccd1 vssd1 X2_sky130_fd_sc_hd__fill_2
XFILLER_75_624 vccd1 vssd1 vccd1 vssd1 X2_sky130_fd_sc_hd__fill_1
XFILLER_47_337 vssd1 vccd1 vssd1 vccd1 X2_sky130_ef_sc_hd__decap_40_12
XTAP_TAPCELL_ROW_58_855 vccd1 vssd1 X2_sky130_fd_sc_hd__tapvpwrvgnd_1
XFILLER_74_189 vssd1 vccd1 vccd1 vssd1 X2_sky130_fd_sc_hd__fill_4
XFILLER_74_77 vssd1 vccd1 vccd1 vssd1 X2_sky130_fd_sc_hd__fill_4
XFILLER_62_307 vccd1 vssd1 vccd1 vssd1 X2_sky130_fd_sc_hd__fill_1
XFILLER_15_223 vccd1 vssd1 vccd1 vssd1 X2_sky130_fd_sc_hd__fill_1
XPHY_EDGE_ROW_92_Right_92 vccd1 vssd1 vccd1 vssd1 X2_sky130_fd_sc_hd__decap_3
XTAP_TAPCELL_ROW_83_1135 vccd1 vssd1 X2_sky130_fd_sc_hd__tapvpwrvgnd_1
XFILLER_90_65 vssd1 vccd1 vssd1 vccd1 X2_sky130_ef_sc_hd__decap_40_12
XFILLER_11_473 vssd1 vccd1 vssd1 vccd1 X2_sky130_ef_sc_hd__decap_40_12
XFILLER_23_81 vssd1 vccd1 vssd1 vccd1 X2_sky130_ef_sc_hd__decap_40_12
XANTENNA__314__A2 _303_/X vssd1 vccd1 vccd1 vssd1 X2_sky130_fd_sc_hd__diode_2
XTAP_TAPCELL_ROW_94_1253 vccd1 vssd1 X2_sky130_fd_sc_hd__tapvpwrvgnd_1
XFILLER_97_237 vssd1 vccd1 vssd1 vccd1 X2_sky130_ef_sc_hd__decap_40_12
XFILLER_2_193 vssd1 vccd1 vccd1 vssd1 X2_sky130_fd_sc_hd__fill_2
XFILLER_38_304 vssd1 vccd1 vccd1 vssd1 X2_sky130_fd_sc_hd__fill_4
XFILLER_38_315 vccd1 vssd1 vccd1 vssd1 X2_sky130_fd_sc_hd__fill_1
XFILLER_78_473 vssd1 vccd1 vccd1 vssd1 X2_sky130_fd_sc_hd__fill_2
XFILLER_66_624 vccd1 vssd1 vccd1 vssd1 X2_sky130_fd_sc_hd__fill_1
XFILLER_0_41 vssd1 vccd1 vssd1 vccd1 X2_sky130_ef_sc_hd__decap_40_12
XFILLER_19_573 vssd1 vccd1 vssd1 vccd1 X2_sky130_ef_sc_hd__decap_40_12
XANTENNA__467__A _473_/A vssd1 vccd1 vccd1 vssd1 X2_sky130_fd_sc_hd__diode_2
XFILLER_65_167 vccd1 vssd1 vccd1 vssd1 X2_sky130_fd_sc_hd__fill_1
XFILLER_53_329 vssd1 vccd1 vccd1 vssd1 X2_sky130_fd_sc_hd__fill_4
XFILLER_0_85 vssd1 vccd1 vssd1 vccd1 X2_sky130_ef_sc_hd__decap_40_12
XFILLER_80_137 vssd1 vccd1 vccd1 vssd1 X2_sky130_fd_sc_hd__fill_2
XFILLER_21_237 vssd1 vccd1 vssd1 vccd1 X2_sky130_ef_sc_hd__decap_40_12
XPHY_EDGE_ROW_100_Right_100 vccd1 vssd1 vccd1 vssd1 X2_sky130_fd_sc_hd__decap_3
XANTENNA__305__A2 _303_/X vssd1 vccd1 vccd1 vssd1 X2_sky130_fd_sc_hd__diode_2
XFILLER_1_609 vssd1 vccd1 vccd1 vssd1 X2_sky130_fd_sc_hd__fill_4
XFILLER_57_602 vccd1 vssd1 vccd1 vssd1 X2_sky130_fd_sc_hd__fill_1
XFILLER_28_15 vssd1 vccd1 vssd1 vccd1 X2_sky130_ef_sc_hd__decap_40_12
XFILLER_29_315 vssd1 vccd1 vccd1 vssd1 X2_sky130_fd_sc_hd__fill_2
XFILLER_29_337 vssd1 vccd1 vssd1 vccd1 X2_sky130_ef_sc_hd__decap_40_12
XFILLER_96_281 vssd1 vccd1 vccd1 vssd1 X2_sky130_fd_sc_hd__fill_2
XFILLER_84_421 vssd1 vccd1 vssd1 vccd1 X2_sky130_ef_sc_hd__decap_40_12
XFILLER_69_473 vssd1 vccd1 vssd1 vccd1 X2_sky130_ef_sc_hd__decap_40_12
XFILLER_57_624 vccd1 vssd1 vccd1 vssd1 X2_sky130_fd_sc_hd__fill_1
XTAP_TAPCELL_ROW_27_516 vccd1 vssd1 X2_sky130_fd_sc_hd__tapvpwrvgnd_1
XFILLER_56_189 vssd1 vccd1 vccd1 vssd1 X2_sky130_fd_sc_hd__fill_4
XTAP_TAPCELL_ROW_55_825 vccd1 vssd1 X2_sky130_fd_sc_hd__tapvpwrvgnd_1
XFILLER_44_307 vccd1 vssd1 vccd1 vssd1 X2_sky130_fd_sc_hd__fill_1
XFILLER_71_137 vssd1 vccd1 vssd1 vccd1 X2_sky130_ef_sc_hd__decap_40_12
XFILLER_40_513 vssd1 vccd1 vssd1 vccd1 X2_sky130_ef_sc_hd__decap_40_12
XFILLER_100_53 vssd1 vccd1 vssd1 vccd1 X2_sky130_ef_sc_hd__decap_40_12
XFILLER_100_97 vssd1 vccd1 vssd1 vccd1 X2_sky130_ef_sc_hd__decap_40_12
XFILLER_4_469 vssd1 vccd1 vccd1 vssd1 X2_sky130_fd_sc_hd__fill_4
XFILLER_69_55 vccd1 vssd1 vccd1 vssd1 X2_sky130_fd_sc_hd__fill_1
XFILLER_79_237 vssd1 vccd1 vssd1 vccd1 X2_sky130_ef_sc_hd__decap_40_12
XANTENNA_input34_A wbs_dat_i[5] vssd1 vccd1 vccd1 vssd1 X2_sky130_fd_sc_hd__diode_2
XTAP_TAPCELL_ROW_7_296 vccd1 vssd1 X2_sky130_fd_sc_hd__tapvpwrvgnd_1
XFILLER_87_281 vssd1 vccd1 vssd1 vccd1 X2_sky130_ef_sc_hd__decap_40_12
XFILLER_48_624 vccd1 vssd1 vccd1 vssd1 X2_sky130_fd_sc_hd__fill_1
XFILLER_48_613 vssd1 vccd1 vccd1 vssd1 X2_sky130_fd_sc_hd__fill_4
XFILLER_90_413 vssd1 vccd1 vccd1 vssd1 X2_sky130_fd_sc_hd__fill_4
XFILLER_47_167 vccd1 vssd1 vccd1 vssd1 X2_sky130_fd_sc_hd__fill_1
XFILLER_18_81 vssd1 vccd1 vccd1 vssd1 X2_sky130_fd_sc_hd__fill_2
XFILLER_90_457 vssd1 vccd1 vssd1 vccd1 X2_sky130_ef_sc_hd__decap_40_12
XFILLER_62_137 vssd1 vccd1 vccd1 vssd1 X2_sky130_fd_sc_hd__fill_2
XFILLER_16_587 vccd1 vssd1 vccd1 vssd1 X2_sky130_fd_sc_hd__fill_1
XANTENNA__607__CLK _607_/CLK vssd1 vccd1 vccd1 vssd1 X2_sky130_fd_sc_hd__diode_2
XFILLER_31_557 vssd1 vccd1 vccd1 vssd1 X2_sky130_fd_sc_hd__fill_2
XFILLER_11_281 vssd1 vccd1 vssd1 vccd1 X2_sky130_ef_sc_hd__decap_40_12
XFILLER_98_513 vssd1 vccd1 vssd1 vccd1 X2_sky130_ef_sc_hd__decap_40_12
XFILLER_98_557 vssd1 vccd1 vssd1 vccd1 X2_sky130_ef_sc_hd__decap_40_12
XFILLER_39_624 vccd1 vssd1 vccd1 vssd1 X2_sky130_fd_sc_hd__fill_1
XFILLER_100_529 vssd1 vccd1 vccd1 vssd1 X2_sky130_fd_sc_hd__fill_2
XFILLER_66_421 vssd1 vccd1 vssd1 vccd1 X2_sky130_ef_sc_hd__decap_40_12
XFILLER_26_307 vccd1 vssd1 vccd1 vssd1 X2_sky130_fd_sc_hd__fill_1
XFILLER_93_284 vssd1 vccd1 vssd1 vccd1 X2_sky130_ef_sc_hd__decap_40_12
XFILLER_53_137 vssd1 vccd1 vssd1 vccd1 X2_sky130_ef_sc_hd__decap_40_12
XFILLER_22_513 vssd1 vccd1 vssd1 vccd1 X2_sky130_ef_sc_hd__decap_40_12
XFILLER_22_557 vssd1 vccd1 vssd1 vccd1 X2_sky130_ef_sc_hd__decap_40_12
XFILLER_61_181 vssd1 vccd1 vssd1 vccd1 X2_sky130_ef_sc_hd__decap_40_12
XTAP_TAPCELL_ROW_32_574 vccd1 vssd1 X2_sky130_fd_sc_hd__tapvpwrvgnd_1
XTAP_TAPCELL_ROW_60_883 vccd1 vssd1 X2_sky130_fd_sc_hd__tapvpwrvgnd_1
XPHY_EDGE_ROW_15_Left_117 vccd1 vssd1 vccd1 vssd1 X2_sky130_fd_sc_hd__decap_3
XFILLER_30_27 vccd1 vssd1 vccd1 vssd1 X2_sky130_fd_sc_hd__fill_1
XFILLER_1_417 vssd1 vccd1 vssd1 vccd1 X2_sky130_ef_sc_hd__decap_40_12
XFILLER_89_557 vssd1 vccd1 vccd1 vssd1 X2_sky130_fd_sc_hd__fill_2
XFILLER_39_47 vssd1 vccd1 vccd1 vssd1 X2_sky130_fd_sc_hd__fill_8
XFILLER_39_69 vssd1 vccd1 vssd1 vccd1 X2_sky130_ef_sc_hd__decap_40_12
XTAP_TAPCELL_ROW_4_266 vccd1 vssd1 X2_sky130_fd_sc_hd__tapvpwrvgnd_1
XPHY_EDGE_ROW_24_Left_126 vccd1 vssd1 vccd1 vssd1 X2_sky130_fd_sc_hd__decap_3
XFILLER_69_281 vssd1 vccd1 vssd1 vccd1 X2_sky130_ef_sc_hd__decap_40_12
XFILLER_29_167 vccd1 vssd1 vccd1 vssd1 X2_sky130_fd_sc_hd__fill_1
XFILLER_84_251 vccd1 vssd1 vccd1 vssd1 X2_sky130_fd_sc_hd__fill_1
XFILLER_72_413 vssd1 vccd1 vccd1 vssd1 X2_sky130_fd_sc_hd__fill_4
XTAP_TAPCELL_ROW_68_972 vccd1 vssd1 X2_sky130_fd_sc_hd__tapvpwrvgnd_1
XFILLER_17_329 vssd1 vccd1 vccd1 vssd1 X2_sky130_fd_sc_hd__fill_4
XFILLER_55_57 vssd1 vccd1 vssd1 vccd1 X2_sky130_ef_sc_hd__decap_40_12
XFILLER_44_137 vssd1 vccd1 vccd1 vssd1 X2_sky130_fd_sc_hd__fill_2
X_470_ vccd1 vssd1 vccd1 vssd1 _470_/Y _473_/A X2_sky130_fd_sc_hd__inv_2
XFILLER_72_457 vssd1 vccd1 vssd1 vccd1 X2_sky130_ef_sc_hd__decap_40_12
XFILLER_25_373 vssd1 vccd1 vssd1 vccd1 X2_sky130_ef_sc_hd__decap_40_12
XTAP_TAPCELL_ROW_80_1105 vccd1 vssd1 X2_sky130_fd_sc_hd__tapvpwrvgnd_1
XFILLER_9_517 vssd1 vccd1 vssd1 vccd1 X2_sky130_ef_sc_hd__decap_40_12
XFILLER_13_557 vssd1 vccd1 vccd1 vssd1 X2_sky130_fd_sc_hd__fill_2
XFILLER_40_365 vccd1 vssd1 vccd1 vssd1 X2_sky130_fd_sc_hd__fill_1
XPHY_EDGE_ROW_33_Left_135 vccd1 vssd1 vccd1 vssd1 X2_sky130_fd_sc_hd__decap_3
XFILLER_40_398 vssd1 vccd1 vssd1 vccd1 X2_sky130_ef_sc_hd__decap_40_12
XFILLER_4_233 vssd1 vccd1 vssd1 vccd1 X2_sky130_ef_sc_hd__decap_40_12
XTAP_TAPCELL_ROW_78_1078 vccd1 vssd1 X2_sky130_fd_sc_hd__tapvpwrvgnd_1
XFILLER_4_277 vssd1 vccd1 vssd1 vccd1 X2_sky130_ef_sc_hd__decap_40_12
XTAP_TAPCELL_ROW_91_1223 vccd1 vssd1 X2_sky130_fd_sc_hd__tapvpwrvgnd_1
XFILLER_95_505 vssd1 vccd1 vssd1 vccd1 X2_sky130_ef_sc_hd__decap_40_12
XFILLER_96_53 vssd1 vccd1 vssd1 vccd1 X2_sky130_ef_sc_hd__decap_40_12
XFILLER_0_461 vssd1 vccd1 vssd1 vccd1 X2_sky130_ef_sc_hd__decap_40_12
XPHY_EDGE_ROW_42_Left_144 vccd1 vssd1 vccd1 vssd1 X2_sky130_fd_sc_hd__decap_3
XFILLER_96_97 vssd1 vccd1 vssd1 vccd1 X2_sky130_ef_sc_hd__decap_40_12
XFILLER_48_443 vssd1 vccd1 vccd1 vssd1 X2_sky130_fd_sc_hd__fill_2
XFILLER_48_421 vssd1 vccd1 vccd1 vssd1 X2_sky130_fd_sc_hd__fill_2
XFILLER_75_273 vssd1 vccd1 vccd1 vssd1 X2_sky130_fd_sc_hd__fill_4
Xhold80 hold80/X _357_/X vccd1 vssd1 vssd1 vccd1 X2_sky130_fd_sc_hd__dlygate4sd3_1
XFILLER_35_137 vssd1 vccd1 vssd1 vccd1 X2_sky130_ef_sc_hd__decap_40_12
XTAP_TAPCELL_ROW_89_1196 vccd1 vssd1 X2_sky130_fd_sc_hd__tapvpwrvgnd_1
XFILLER_90_221 vssd1 vccd1 vssd1 vccd1 X2_sky130_ef_sc_hd__decap_40_12
XFILLER_48_498 vccd1 vssd1 vccd1 vssd1 X2_sky130_fd_sc_hd__fill_1
XFILLER_90_265 vccd1 vssd1 vccd1 vssd1 X2_sky130_fd_sc_hd__fill_1
X_599_ vccd1 vssd1 vccd1 vssd1 _599_/Q _519_/Y _599_/D _599_/CLK X2_sky130_fd_sc_hd__dfstp_1
XFILLER_31_321 vssd1 vccd1 vssd1 vccd1 X2_sky130_ef_sc_hd__decap_40_12
XFILLER_43_181 vssd1 vccd1 vccd1 vssd1 X2_sky130_fd_sc_hd__fill_8
XPHY_EDGE_ROW_51_Left_153 vccd1 vssd1 vccd1 vssd1 X2_sky130_fd_sc_hd__decap_3
XFILLER_77_3 vssd1 vccd1 vssd1 vccd1 X2_sky130_ef_sc_hd__decap_40_12
XFILLER_98_365 vssd1 vccd1 vccd1 vssd1 X2_sky130_fd_sc_hd__fill_2
XPHY_EDGE_ROW_60_Left_162 vccd1 vssd1 vccd1 vssd1 X2_sky130_fd_sc_hd__decap_3
XFILLER_100_315 vccd1 vssd1 vccd1 vssd1 X2_sky130_fd_sc_hd__fill_1
XFILLER_66_251 vccd1 vssd1 vccd1 vssd1 X2_sky130_fd_sc_hd__fill_1
XTAP_TAPCELL_ROW_1_236 vccd1 vssd1 X2_sky130_fd_sc_hd__tapvpwrvgnd_1
XFILLER_26_137 vssd1 vccd1 vccd1 vssd1 X2_sky130_fd_sc_hd__fill_2
XTAP_TAPCELL_ROW_37_622 vccd1 vssd1 X2_sky130_fd_sc_hd__tapvpwrvgnd_1
XFILLER_81_221 vssd1 vccd1 vccd1 vssd1 X2_sky130_fd_sc_hd__fill_2
XTAP_TAPCELL_ROW_65_931 vccd1 vssd1 X2_sky130_fd_sc_hd__tapvpwrvgnd_1
XFILLER_54_435 vssd1 vccd1 vccd1 vssd1 X2_sky130_fd_sc_hd__fill_2
XFILLER_54_413 vssd1 vccd1 vccd1 vssd1 X2_sky130_fd_sc_hd__fill_4
XFILLER_25_27 vssd1 vccd1 vssd1 vccd1 X2_sky130_ef_sc_hd__decap_40_12
XFILLER_54_468 vssd1 vccd1 vccd1 vssd1 X2_sky130_fd_sc_hd__fill_8
XFILLER_54_457 vssd1 vccd1 vccd1 vssd1 X2_sky130_fd_sc_hd__fill_4
XFILLER_42_619 vssd1 vccd1 vccd1 vssd1 X2_sky130_fd_sc_hd__fill_2
XFILLER_22_321 vssd1 vccd1 vssd1 vccd1 X2_sky130_ef_sc_hd__decap_40_12
XFILLER_22_365 vssd1 vccd1 vssd1 vccd1 X2_sky130_ef_sc_hd__decap_40_12
XFILLER_41_15 vssd1 vccd1 vssd1 vccd1 X2_sky130_ef_sc_hd__decap_40_12
XTAP_TAPCELL_ROW_9_314 vccd1 vssd1 X2_sky130_fd_sc_hd__tapvpwrvgnd_1
XFILLER_1_225 vssd1 vccd1 vssd1 vccd1 X2_sky130_ef_sc_hd__decap_40_12
XFILLER_89_321 vssd1 vccd1 vssd1 vccd1 X2_sky130_ef_sc_hd__decap_40_12
XFILLER_77_505 vssd1 vccd1 vssd1 vccd1 X2_sky130_ef_sc_hd__decap_40_12
XFILLER_1_269 vssd1 vccd1 vccd1 vssd1 X2_sky130_fd_sc_hd__fill_4
XFILLER_49_218 vssd1 vccd1 vccd1 vssd1 X2_sky130_fd_sc_hd__fill_4
XFILLER_17_137 vssd1 vccd1 vssd1 vccd1 X2_sky130_ef_sc_hd__decap_40_12
XFILLER_72_221 vssd1 vccd1 vssd1 vccd1 X2_sky130_ef_sc_hd__decap_40_12
XFILLER_57_273 vssd1 vccd1 vccd1 vssd1 X2_sky130_fd_sc_hd__fill_4
XFILLER_33_608 vssd1 vccd1 vccd1 vssd1 X2_sky130_fd_sc_hd__fill_2
X_522_ vccd1 vssd1 vccd1 vssd1 _522_/Y _525_/A X2_sky130_fd_sc_hd__inv_2
X_453_ vccd1 vssd1 vccd1 vssd1 _453_/Y _473_/A X2_sky130_fd_sc_hd__inv_2
XFILLER_72_265 vssd1 vccd1 vssd1 vccd1 X2_sky130_ef_sc_hd__decap_40_12
XFILLER_25_181 vssd1 vccd1 vssd1 vccd1 X2_sky130_ef_sc_hd__decap_40_12
XFILLER_82_77 vssd1 vccd1 vccd1 vssd1 X2_sky130_fd_sc_hd__fill_4
XFILLER_15_93 vssd1 vccd1 vssd1 vccd1 X2_sky130_ef_sc_hd__decap_40_12
X_384_ vccd1 vssd1 _413_/A _551_/Q _536_/Q vccd1 vssd1 X2_sky130_fd_sc_hd__xor2_2
XFILLER_5_553 vssd1 vccd1 vccd1 vssd1 X2_sky130_fd_sc_hd__fill_4
XFILLER_31_81 vssd1 vccd1 vssd1 vccd1 X2_sky130_ef_sc_hd__decap_40_12
XFILLER_5_597 vssd1 vccd1 vssd1 vccd1 X2_sky130_ef_sc_hd__decap_40_12
XFILLER_95_346 vssd1 vccd1 vccd1 vssd1 X2_sky130_fd_sc_hd__fill_2
XFILLER_36_402 vssd1 vccd1 vccd1 vssd1 X2_sky130_fd_sc_hd__fill_2
XFILLER_48_251 vccd1 vssd1 vccd1 vssd1 X2_sky130_fd_sc_hd__fill_1
XFILLER_36_413 vssd1 vccd1 vccd1 vssd1 X2_sky130_fd_sc_hd__fill_2
XANTENNA_clkbuf_3_0__f_wb_clk_i_A clkbuf_0_wb_clk_i/X vssd1 vccd1 vccd1 vssd1 X2_sky130_fd_sc_hd__diode_2
XFILLER_91_541 vssd1 vccd1 vssd1 vccd1 X2_sky130_ef_sc_hd__decap_40_12
XTAP_TAPCELL_ROW_62_901 vccd1 vssd1 X2_sky130_fd_sc_hd__tapvpwrvgnd_1
XFILLER_91_585 vssd1 vccd1 vssd1 vccd1 X2_sky130_ef_sc_hd__decap_40_12
XANTENNA__475__A _521_/A vssd1 vccd1 vccd1 vssd1 X2_sky130_fd_sc_hd__diode_2
XFILLER_51_449 vssd1 vccd1 vssd1 vccd1 X2_sky130_ef_sc_hd__decap_40_12
XTAP_TAPCELL_ROW_14_371 vccd1 vssd1 X2_sky130_fd_sc_hd__tapvpwrvgnd_1
XTAP_TAPCELL_ROW_42_680 vccd1 vssd1 X2_sky130_fd_sc_hd__tapvpwrvgnd_1
XFILLER_101_613 vssd1 vccd1 vccd1 vssd1 X2_sky130_fd_sc_hd__fill_2
XFILLER_59_505 vssd1 vccd1 vssd1 vccd1 X2_sky130_ef_sc_hd__decap_40_12
XFILLER_98_195 vccd1 vssd1 vccd1 vssd1 X2_sky130_fd_sc_hd__fill_1
XFILLER_86_357 vssd1 vccd1 vccd1 vssd1 X2_sky130_fd_sc_hd__fill_4
XFILLER_36_15 vssd1 vccd1 vssd1 vccd1 X2_sky130_ef_sc_hd__decap_40_12
XFILLER_39_295 vssd1 vccd1 vccd1 vssd1 X2_sky130_fd_sc_hd__fill_4
XFILLER_100_189 vssd1 vccd1 vccd1 vssd1 X2_sky130_fd_sc_hd__fill_4
XFILLER_67_593 vssd1 vccd1 vccd1 vssd1 X2_sky130_fd_sc_hd__fill_2
XFILLER_54_232 vssd1 vccd1 vssd1 vccd1 X2_sky130_ef_sc_hd__decap_40_12
XFILLER_82_585 vssd1 vccd1 vccd1 vssd1 X2_sky130_fd_sc_hd__fill_2
XFILLER_54_287 vssd1 vccd1 vssd1 vccd1 X2_sky130_ef_sc_hd__decap_40_12
XFILLER_50_471 vssd1 vccd1 vccd1 vssd1 X2_sky130_fd_sc_hd__fill_4
XFILLER_10_357 vssd1 vccd1 vccd1 vssd1 X2_sky130_fd_sc_hd__fill_4
XFILLER_22_195 vccd1 vssd1 vccd1 vssd1 X2_sky130_fd_sc_hd__fill_1
XFILLER_2_501 vssd1 vccd1 vssd1 vccd1 X2_sky130_ef_sc_hd__decap_40_12
XTAP_TAPCELL_ROW_75_1048 vccd1 vssd1 X2_sky130_fd_sc_hd__tapvpwrvgnd_1
XFILLER_2_545 vssd1 vccd1 vssd1 vccd1 X2_sky130_ef_sc_hd__decap_40_12
XFILLER_7_3 vssd1 vccd1 vssd1 vccd1 X2_sky130_ef_sc_hd__decap_40_12
XFILLER_2_589 vssd1 vccd1 vssd1 vccd1 X2_sky130_ef_sc_hd__decap_40_12
XFILLER_77_55 vccd1 vssd1 vccd1 vssd1 X2_sky130_fd_sc_hd__fill_1
XFILLER_77_335 vccd1 vssd1 vccd1 vssd1 X2_sky130_fd_sc_hd__fill_1
XFILLER_92_305 vssd1 vccd1 vccd1 vssd1 X2_sky130_fd_sc_hd__fill_2
XFILLER_18_413 vssd1 vccd1 vccd1 vssd1 X2_sky130_fd_sc_hd__fill_4
XFILLER_92_338 vssd1 vccd1 vssd1 vccd1 X2_sky130_ef_sc_hd__decap_40_12
XFILLER_18_457 vssd1 vccd1 vssd1 vccd1 X2_sky130_ef_sc_hd__decap_40_12
XFILLER_73_541 vssd1 vccd1 vssd1 vccd1 X2_sky130_ef_sc_hd__decap_40_12
XFILLER_45_232 vssd1 vccd1 vccd1 vssd1 X2_sky130_fd_sc_hd__fill_8
X_505_ vccd1 vssd1 vccd1 vssd1 _505_/Y _527_/A X2_sky130_fd_sc_hd__inv_2
XTAP_TAPCELL_ROW_86_1166 vccd1 vssd1 X2_sky130_fd_sc_hd__tapvpwrvgnd_1
XFILLER_26_81 vssd1 vccd1 vccd1 vssd1 X2_sky130_fd_sc_hd__fill_2
XFILLER_33_449 vssd1 vccd1 vssd1 vccd1 X2_sky130_ef_sc_hd__decap_40_12
XFILLER_60_268 vccd1 vssd1 vccd1 vssd1 X2_sky130_fd_sc_hd__fill_1
X_436_ vccd1 vssd1 vssd1 vccd1 _436_/A _544_/D _436_/B X2_sky130_fd_sc_hd__nand2_1
XFILLER_9_111 vccd1 vssd1 vccd1 vssd1 X2_sky130_fd_sc_hd__fill_1
X_367_ vccd1 vssd1 vssd1 vccd1 _532_/Q _547_/Q _368_/D X2_sky130_fd_sc_hd__nand2b_1
XTAP_TAPCELL_ROW_11_341 vccd1 vssd1 X2_sky130_fd_sc_hd__tapvpwrvgnd_1
X_298_ vssd1 vccd1 vccd1 vssd1 _575_/D hold78/X _299_/S _298_/A0 X2_sky130_fd_sc_hd__mux2_1
XTAP_TAPCELL_ROW_97_1284 vccd1 vssd1 X2_sky130_fd_sc_hd__tapvpwrvgnd_1
XFILLER_5_361 vssd1 vccd1 vssd1 vccd1 X2_sky130_ef_sc_hd__decap_40_12
XFILLER_95_165 vssd1 vccd1 vccd1 vssd1 X2_sky130_fd_sc_hd__fill_2
XFILLER_83_305 vssd1 vccd1 vssd1 vccd1 X2_sky130_ef_sc_hd__decap_40_12
XFILLER_83_349 vssd1 vccd1 vssd1 vccd1 X2_sky130_ef_sc_hd__decap_40_12
XFILLER_49_571 vssd1 vccd1 vccd1 vssd1 X2_sky130_fd_sc_hd__fill_2
XTAP_TAPCELL_ROW_19_430 vccd1 vssd1 X2_sky130_fd_sc_hd__tapvpwrvgnd_1
XFILLER_64_530 vssd1 vccd1 vccd1 vssd1 X2_sky130_fd_sc_hd__fill_2
XFILLER_91_393 vssd1 vccd1 vssd1 vccd1 X2_sky130_ef_sc_hd__decap_40_12
XFILLER_51_268 vccd1 vssd1 vccd1 vssd1 X2_sky130_fd_sc_hd__fill_1
XANTENNA__335__B1 _317_/C vssd1 vccd1 vccd1 vssd1 X2_sky130_fd_sc_hd__diode_2
XFILLER_101_421 vssd1 vccd1 vccd1 vssd1 X2_sky130_fd_sc_hd__fill_8
XFILLER_86_121 vssd1 vccd1 vssd1 vccd1 X2_sky130_ef_sc_hd__decap_40_12
XFILLER_86_165 vssd1 vccd1 vssd1 vccd1 X2_sky130_ef_sc_hd__decap_40_12
XFILLER_74_305 vssd1 vccd1 vccd1 vssd1 X2_sky130_fd_sc_hd__fill_2
XFILLER_47_69 vssd1 vccd1 vssd1 vccd1 X2_sky130_ef_sc_hd__decap_40_12
XFILLER_47_47 vssd1 vccd1 vccd1 vssd1 X2_sky130_fd_sc_hd__fill_8
XFILLER_27_221 vssd1 vccd1 vccd1 vssd1 X2_sky130_fd_sc_hd__fill_2
XFILLER_55_541 vssd1 vccd1 vssd1 vccd1 X2_sky130_ef_sc_hd__decap_40_12
XFILLER_15_405 vssd1 vccd1 vssd1 vccd1 X2_sky130_ef_sc_hd__decap_40_12
XFILLER_55_563 vccd1 vssd1 vccd1 vssd1 X2_sky130_fd_sc_hd__fill_1
XFILLER_15_449 vssd1 vccd1 vssd1 vccd1 X2_sky130_ef_sc_hd__decap_40_12
XFILLER_70_533 vssd1 vccd1 vssd1 vccd1 X2_sky130_ef_sc_hd__decap_40_12
XFILLER_63_57 vssd1 vccd1 vssd1 vccd1 X2_sky130_ef_sc_hd__decap_40_12
XFILLER_30_419 vccd1 vssd1 vccd1 vssd1 X2_sky130_fd_sc_hd__fill_1
XPHY_EDGE_ROW_7_Left_109 vccd1 vssd1 vccd1 vssd1 X2_sky130_fd_sc_hd__decap_3
XTAP_TAPCELL_ROW_25_499 vccd1 vssd1 X2_sky130_fd_sc_hd__tapvpwrvgnd_1
XFILLER_7_615 vccd1 vssd1 vccd1 vssd1 X2_sky130_fd_sc_hd__fill_1
XFILLER_10_121 vssd1 vccd1 vssd1 vccd1 X2_sky130_ef_sc_hd__decap_40_12
XFILLER_10_165 vssd1 vccd1 vssd1 vccd1 X2_sky130_ef_sc_hd__decap_40_12
XANTENNA__326__B1 _317_/C vssd1 vccd1 vccd1 vssd1 X2_sky130_fd_sc_hd__diode_2
XFILLER_12_83 vccd1 vssd1 vccd1 vssd1 X2_sky130_fd_sc_hd__fill_1
XFILLER_88_65 vssd1 vccd1 vssd1 vccd1 X2_sky130_ef_sc_hd__decap_40_12
Xtop_soc_67 user_irq[2] top_soc_67/HI vccd1 vssd1 vssd1 vccd1 X2_sky130_fd_sc_hd__conb_1
Xtop_soc_78 wbs_dat_o[26] top_soc_78/HI vccd1 vssd1 vssd1 vccd1 X2_sky130_fd_sc_hd__conb_1
XFILLER_77_165 vssd1 vccd1 vccd1 vssd1 X2_sky130_fd_sc_hd__fill_2
XFILLER_18_221 vssd1 vccd1 vssd1 vccd1 X2_sky130_ef_sc_hd__decap_40_12
XFILLER_18_265 vssd1 vccd1 vssd1 vccd1 X2_sky130_ef_sc_hd__decap_40_12
XTAP_TAPCELL_ROW_16_400 vccd1 vssd1 X2_sky130_fd_sc_hd__tapvpwrvgnd_1
XFILLER_73_393 vssd1 vccd1 vssd1 vccd1 X2_sky130_ef_sc_hd__decap_40_12
XFILLER_33_246 vssd1 vccd1 vccd1 vssd1 X2_sky130_fd_sc_hd__fill_2
X_419_ vssd1 vccd1 vssd1 vccd1 _419_/X _406_/C _420_/A _418_/X X2_sky130_fd_sc_hd__a21bo_1
XTAP_TAPCELL_ROW_99_1313 vccd1 vssd1 X2_sky130_fd_sc_hd__tapvpwrvgnd_1
XFILLER_68_121 vssd1 vccd1 vssd1 vccd1 X2_sky130_ef_sc_hd__decap_40_12
XFILLER_83_113 vssd1 vccd1 vssd1 vccd1 X2_sky130_ef_sc_hd__decap_40_12
XFILLER_68_165 vssd1 vccd1 vssd1 vccd1 X2_sky130_ef_sc_hd__decap_40_12
XFILLER_17_39 vssd1 vccd1 vssd1 vccd1 X2_sky130_ef_sc_hd__decap_40_12
XFILLER_37_585 vssd1 vccd1 vccd1 vssd1 X2_sky130_fd_sc_hd__fill_2
XFILLER_52_533 vssd1 vccd1 vssd1 vccd1 X2_sky130_ef_sc_hd__decap_40_12
XFILLER_12_419 vccd1 vssd1 vccd1 vssd1 X2_sky130_fd_sc_hd__fill_1
XFILLER_52_555 vccd1 vssd1 vccd1 vssd1 X2_sky130_fd_sc_hd__fill_1
XFILLER_33_27 vssd1 vccd1 vssd1 vccd1 X2_sky130_ef_sc_hd__decap_40_12
XTAP_TAPCELL_ROW_22_458 vccd1 vssd1 X2_sky130_fd_sc_hd__tapvpwrvgnd_1
XTAP_TAPCELL_ROW_50_767 vccd1 vssd1 X2_sky130_fd_sc_hd__tapvpwrvgnd_1
XANTENNA__308__B1 _304_/X vssd1 vccd1 vccd1 vssd1 X2_sky130_fd_sc_hd__diode_2
XTAP_TAPCELL_ROW_72_1007 vccd1 vssd1 X2_sky130_fd_sc_hd__tapvpwrvgnd_1
XFILLER_87_441 vssd1 vccd1 vccd1 vssd1 X2_sky130_fd_sc_hd__fill_4
XFILLER_87_485 vssd1 vccd1 vssd1 vccd1 X2_sky130_ef_sc_hd__decap_40_12
XFILLER_101_262 vssd1 vccd1 vccd1 vssd1 X2_sky130_fd_sc_hd__fill_4
XFILLER_101_251 vccd1 vssd1 vccd1 vssd1 X2_sky130_fd_sc_hd__fill_1
XFILLER_59_165 vssd1 vccd1 vccd1 vssd1 X2_sky130_fd_sc_hd__fill_2
XTAP_TAPCELL_ROW_58_856 vccd1 vssd1 X2_sky130_fd_sc_hd__tapvpwrvgnd_1
XFILLER_47_349 vssd1 vccd1 vccd1 vssd1 X2_sky130_fd_sc_hd__fill_4
XFILLER_28_585 vssd1 vccd1 vccd1 vssd1 X2_sky130_fd_sc_hd__fill_2
XTAP_TAPCELL_ROW_83_1136 vccd1 vssd1 X2_sky130_fd_sc_hd__tapvpwrvgnd_1
XFILLER_55_393 vssd1 vccd1 vssd1 vccd1 X2_sky130_ef_sc_hd__decap_40_12
XFILLER_70_363 vccd1 vssd1 vccd1 vssd1 X2_sky130_fd_sc_hd__fill_1
XFILLER_15_279 vccd1 vssd1 vccd1 vssd1 X2_sky130_fd_sc_hd__fill_1
XFILLER_11_441 vssd1 vccd1 vccd1 vssd1 X2_sky130_fd_sc_hd__fill_4
XFILLER_30_249 vssd1 vccd1 vccd1 vssd1 X2_sky130_fd_sc_hd__fill_2
XFILLER_90_77 vssd1 vccd1 vccd1 vssd1 X2_sky130_fd_sc_hd__fill_4
XFILLER_7_445 vssd1 vccd1 vccd1 vssd1 X2_sky130_fd_sc_hd__fill_2
XFILLER_11_485 vssd1 vccd1 vssd1 vccd1 X2_sky130_ef_sc_hd__decap_40_12
XFILLER_23_93 vssd1 vccd1 vssd1 vccd1 X2_sky130_ef_sc_hd__decap_40_12
XTAP_TAPCELL_ROW_94_1254 vccd1 vssd1 X2_sky130_fd_sc_hd__tapvpwrvgnd_1
XANTENNA__536__CLK _553_/CLK vssd1 vccd1 vccd1 vssd1 X2_sky130_fd_sc_hd__diode_2
XFILLER_97_205 vssd1 vccd1 vssd1 vccd1 X2_sky130_ef_sc_hd__decap_40_12
XFILLER_97_249 vssd1 vccd1 vssd1 vccd1 X2_sky130_ef_sc_hd__decap_40_12
XFILLER_66_614 vssd1 vccd1 vccd1 vssd1 X2_sky130_fd_sc_hd__fill_2
XFILLER_65_113 vssd1 vccd1 vssd1 vccd1 X2_sky130_ef_sc_hd__decap_40_12
XFILLER_19_541 vssd1 vccd1 vssd1 vccd1 X2_sky130_ef_sc_hd__decap_40_12
XFILLER_0_53 vssd1 vccd1 vccd1 vssd1 X2_sky130_fd_sc_hd__fill_2
XFILLER_81_617 vssd1 vccd1 vccd1 vssd1 X2_sky130_fd_sc_hd__fill_8
XFILLER_19_585 vssd1 vccd1 vssd1 vccd1 X2_sky130_ef_sc_hd__decap_40_12
XFILLER_34_511 vccd1 vssd1 vccd1 vssd1 X2_sky130_fd_sc_hd__fill_1
XFILLER_34_533 vssd1 vccd1 vssd1 vccd1 X2_sky130_ef_sc_hd__decap_40_12
XFILLER_0_97 vssd1 vccd1 vssd1 vccd1 X2_sky130_ef_sc_hd__decap_40_12
XFILLER_61_352 vssd1 vccd1 vssd1 vccd1 X2_sky130_ef_sc_hd__decap_40_12
XFILLER_21_205 vssd1 vccd1 vssd1 vccd1 X2_sky130_ef_sc_hd__decap_40_12
XFILLER_9_51 vssd1 vccd1 vccd1 vssd1 X2_sky130_fd_sc_hd__fill_4
XFILLER_21_249 vssd1 vccd1 vssd1 vccd1 X2_sky130_ef_sc_hd__decap_40_12
XFILLER_0_109 vssd1 vccd1 vccd1 vssd1 X2_sky130_fd_sc_hd__fill_2
XFILLER_88_249 vssd1 vccd1 vccd1 vssd1 X2_sky130_fd_sc_hd__fill_2
XFILLER_69_441 vssd1 vccd1 vccd1 vssd1 X2_sky130_fd_sc_hd__fill_4
XFILLER_28_27 vccd1 vssd1 vccd1 vssd1 X2_sky130_fd_sc_hd__fill_1
XFILLER_69_485 vssd1 vccd1 vssd1 vccd1 X2_sky130_ef_sc_hd__decap_40_12
XFILLER_57_614 vssd1 vccd1 vccd1 vssd1 X2_sky130_fd_sc_hd__fill_2
XFILLER_29_349 vssd1 vccd1 vssd1 vccd1 X2_sky130_ef_sc_hd__decap_40_12
XFILLER_84_433 vssd1 vccd1 vssd1 vccd1 X2_sky130_ef_sc_hd__decap_40_12
XTAP_TAPCELL_ROW_27_517 vccd1 vssd1 X2_sky130_fd_sc_hd__tapvpwrvgnd_1
XFILLER_84_477 vssd1 vccd1 vssd1 vccd1 X2_sky130_ef_sc_hd__decap_40_12
XFILLER_71_105 vssd1 vccd1 vccd1 vssd1 X2_sky130_fd_sc_hd__fill_4
XTAP_TAPCELL_ROW_55_826 vccd1 vssd1 X2_sky130_fd_sc_hd__tapvpwrvgnd_1
XFILLER_37_393 vssd1 vccd1 vccd1 vssd1 X2_sky130_fd_sc_hd__fill_2
XFILLER_71_149 vssd1 vccd1 vssd1 vccd1 X2_sky130_ef_sc_hd__decap_40_12
XFILLER_44_15 vssd1 vccd1 vssd1 vccd1 X2_sky130_ef_sc_hd__decap_40_12
XFILLER_52_352 vssd1 vccd1 vssd1 vccd1 X2_sky130_ef_sc_hd__decap_40_12
XFILLER_52_341 vssd1 vccd1 vccd1 vssd1 X2_sky130_fd_sc_hd__fill_8
XFILLER_40_525 vssd1 vccd1 vccd1 vssd1 X2_sky130_fd_sc_hd__fill_4
XFILLER_8_209 vssd1 vccd1 vssd1 vccd1 X2_sky130_ef_sc_hd__decap_40_12
XFILLER_12_249 vssd1 vccd1 vccd1 vssd1 X2_sky130_fd_sc_hd__fill_2
XFILLER_100_65 vssd1 vccd1 vssd1 vccd1 X2_sky130_ef_sc_hd__decap_40_12
XANTENNA__559__CLK _607_/CLK vssd1 vccd1 vccd1 vssd1 X2_sky130_fd_sc_hd__diode_2
XFILLER_79_205 vssd1 vccd1 vssd1 vccd1 X2_sky130_ef_sc_hd__decap_40_12
XFILLER_79_249 vssd1 vccd1 vssd1 vccd1 X2_sky130_ef_sc_hd__decap_40_12
XTAP_TAPCELL_ROW_7_297 vccd1 vssd1 X2_sky130_fd_sc_hd__tapvpwrvgnd_1
XFILLER_47_113 vssd1 vccd1 vssd1 vccd1 X2_sky130_ef_sc_hd__decap_40_12
XFILLER_87_293 vssd1 vccd1 vssd1 vccd1 X2_sky130_ef_sc_hd__decap_40_12
XFILLER_85_55 vccd1 vssd1 vccd1 vssd1 X2_sky130_fd_sc_hd__fill_1
XANTENNA_input27_A wbs_dat_i[13] vssd1 vccd1 vccd1 vssd1 X2_sky130_fd_sc_hd__diode_2
XFILLER_63_617 vccd1 vssd1 vccd1 vssd1 X2_sky130_fd_sc_hd__fill_1
XFILLER_16_533 vssd1 vccd1 vssd1 vccd1 X2_sky130_ef_sc_hd__decap_40_12
XFILLER_90_469 vssd1 vccd1 vccd1 vssd1 X2_sky130_fd_sc_hd__fill_4
XFILLER_31_503 vccd1 vssd1 vccd1 vssd1 X2_sky130_fd_sc_hd__fill_1
XFILLER_31_569 vssd1 vccd1 vccd1 vssd1 X2_sky130_fd_sc_hd__fill_2
XFILLER_34_81 vssd1 vccd1 vccd1 vssd1 X2_sky130_fd_sc_hd__fill_2
XFILLER_70_193 vssd1 vccd1 vccd1 vssd1 X2_sky130_fd_sc_hd__fill_2
XFILLER_11_293 vssd1 vccd1 vssd1 vccd1 X2_sky130_ef_sc_hd__decap_40_12
XFILLER_98_525 vssd1 vccd1 vccd1 vssd1 X2_sky130_fd_sc_hd__fill_4
XFILLER_98_569 vssd1 vccd1 vssd1 vccd1 X2_sky130_ef_sc_hd__decap_40_12
XFILLER_22_3 vssd1 vccd1 vssd1 vccd1 X2_sky130_ef_sc_hd__decap_40_12
XFILLER_66_433 vssd1 vccd1 vssd1 vccd1 X2_sky130_ef_sc_hd__decap_40_12
XFILLER_38_157 vssd1 vccd1 vccd1 vssd1 X2_sky130_fd_sc_hd__fill_2
XFILLER_66_477 vssd1 vccd1 vssd1 vccd1 X2_sky130_ef_sc_hd__decap_40_12
XFILLER_53_105 vssd1 vccd1 vccd1 vssd1 X2_sky130_fd_sc_hd__fill_4
XFILLER_19_393 vssd1 vccd1 vssd1 vccd1 X2_sky130_ef_sc_hd__decap_40_12
XFILLER_93_296 vssd1 vccd1 vssd1 vccd1 X2_sky130_ef_sc_hd__decap_40_12
XFILLER_81_447 vccd1 vssd1 vccd1 vssd1 X2_sky130_fd_sc_hd__fill_1
XFILLER_34_330 vssd1 vccd1 vccd1 vssd1 X2_sky130_fd_sc_hd__fill_4
XFILLER_34_341 vccd1 vssd1 vccd1 vssd1 X2_sky130_fd_sc_hd__fill_1
XFILLER_53_149 vssd1 vccd1 vssd1 vccd1 X2_sky130_ef_sc_hd__decap_40_12
XFILLER_22_525 vssd1 vccd1 vccd1 vssd1 X2_sky130_fd_sc_hd__fill_4
XFILLER_34_363 vccd1 vssd1 vccd1 vssd1 X2_sky130_fd_sc_hd__fill_1
XFILLER_14_29 vssd1 vccd1 vssd1 vccd1 X2_sky130_ef_sc_hd__decap_40_12
XFILLER_22_569 vssd1 vccd1 vssd1 vccd1 X2_sky130_ef_sc_hd__decap_40_12
XFILLER_61_193 vssd1 vccd1 vssd1 vccd1 X2_sky130_ef_sc_hd__decap_40_12
XTAP_TAPCELL_ROW_32_575 vccd1 vssd1 X2_sky130_fd_sc_hd__tapvpwrvgnd_1
XTAP_TAPCELL_ROW_60_884 vccd1 vssd1 X2_sky130_fd_sc_hd__tapvpwrvgnd_1
XFILLER_89_503 vccd1 vssd1 vccd1 vssd1 X2_sky130_fd_sc_hd__fill_1
XFILLER_1_429 vssd1 vccd1 vssd1 vccd1 X2_sky130_ef_sc_hd__decap_40_12
XFILLER_29_113 vssd1 vccd1 vssd1 vccd1 X2_sky130_ef_sc_hd__decap_40_12
XFILLER_69_293 vssd1 vccd1 vssd1 vccd1 X2_sky130_ef_sc_hd__decap_40_12
XTAP_TAPCELL_ROW_4_267 vccd1 vssd1 X2_sky130_fd_sc_hd__tapvpwrvgnd_1
XTAP_TAPCELL_ROW_68_973 vccd1 vssd1 X2_sky130_fd_sc_hd__tapvpwrvgnd_1
XFILLER_45_617 vssd1 vccd1 vccd1 vssd1 X2_sky130_fd_sc_hd__fill_2
XFILLER_84_296 vssd1 vccd1 vccd1 vssd1 X2_sky130_fd_sc_hd__fill_2
XFILLER_84_274 vssd1 vccd1 vccd1 vssd1 X2_sky130_fd_sc_hd__fill_2
XFILLER_55_69 vssd1 vccd1 vssd1 vccd1 X2_sky130_ef_sc_hd__decap_40_12
XFILLER_72_469 vssd1 vccd1 vccd1 vssd1 X2_sky130_fd_sc_hd__fill_4
XFILLER_13_503 vccd1 vssd1 vccd1 vssd1 X2_sky130_fd_sc_hd__fill_1
XFILLER_25_385 vssd1 vccd1 vccd1 vssd1 X2_sky130_fd_sc_hd__fill_4
XFILLER_52_193 vssd1 vccd1 vccd1 vssd1 X2_sky130_fd_sc_hd__fill_2
XFILLER_9_529 vssd1 vccd1 vssd1 vccd1 X2_sky130_ef_sc_hd__decap_40_12
XFILLER_71_57 vssd1 vccd1 vssd1 vccd1 X2_sky130_ef_sc_hd__decap_40_12
XFILLER_4_245 vssd1 vccd1 vccd1 vssd1 X2_sky130_fd_sc_hd__fill_4
XTAP_TAPCELL_ROW_78_1079 vccd1 vssd1 X2_sky130_fd_sc_hd__tapvpwrvgnd_1
XFILLER_4_289 vssd1 vccd1 vssd1 vccd1 X2_sky130_ef_sc_hd__decap_40_12
XFILLER_20_83 vccd1 vssd1 vccd1 vssd1 X2_sky130_fd_sc_hd__fill_1
XTAP_TAPCELL_ROW_91_1224 vccd1 vssd1 X2_sky130_fd_sc_hd__tapvpwrvgnd_1
XFILLER_0_473 vssd1 vccd1 vccd1 vssd1 X2_sky130_fd_sc_hd__fill_2
XFILLER_95_517 vssd1 vccd1 vssd1 vccd1 X2_sky130_ef_sc_hd__decap_40_12
XFILLER_96_65 vssd1 vccd1 vssd1 vccd1 X2_sky130_ef_sc_hd__decap_40_12
XFILLER_29_81 vssd1 vccd1 vssd1 vccd1 X2_sky130_ef_sc_hd__decap_40_12
Xhold70 hold70/X _579_/Q vccd1 vssd1 vssd1 vccd1 X2_sky130_fd_sc_hd__dlygate4sd3_1
Xhold81 _426_/B _358_/Y vccd1 vssd1 vssd1 vccd1 X2_sky130_fd_sc_hd__dlygate4sd3_1
XFILLER_48_477 vccd1 vssd1 vccd1 vssd1 X2_sky130_fd_sc_hd__fill_1
XFILLER_35_105 vssd1 vccd1 vccd1 vssd1 X2_sky130_fd_sc_hd__fill_4
XTAP_TAPCELL_ROW_89_1197 vccd1 vssd1 X2_sky130_fd_sc_hd__tapvpwrvgnd_1
XFILLER_63_447 vccd1 vssd1 vccd1 vssd1 X2_sky130_fd_sc_hd__fill_1
XFILLER_35_149 vssd1 vccd1 vssd1 vccd1 X2_sky130_ef_sc_hd__decap_40_12
XFILLER_90_233 vssd1 vccd1 vssd1 vccd1 X2_sky130_ef_sc_hd__decap_40_12
XFILLER_16_363 vccd1 vssd1 vccd1 vssd1 X2_sky130_fd_sc_hd__fill_1
X_598_ vccd1 vssd1 vccd1 vssd1 _598_/Q _518_/Y _598_/D _599_/CLK X2_sky130_fd_sc_hd__dfstp_1
XFILLER_31_333 vssd1 vccd1 vccd1 vssd1 X2_sky130_fd_sc_hd__fill_2
XTAP_TAPCELL_ROW_100_1320 vccd1 vssd1 X2_sky130_fd_sc_hd__tapvpwrvgnd_1
XANTENNA__534__Q _534_/Q vssd1 vccd1 vccd1 vssd1 X2_sky130_fd_sc_hd__diode_2
XFILLER_6_41 vssd1 vccd1 vssd1 vccd1 X2_sky130_ef_sc_hd__decap_40_12
XANTENNA_1 _535_/D vssd1 vccd1 vccd1 vssd1 X2_sky130_fd_sc_hd__diode_2
XFILLER_6_85 vssd1 vccd1 vssd1 vccd1 X2_sky130_ef_sc_hd__decap_40_12
XFILLER_98_377 vssd1 vccd1 vccd1 vssd1 X2_sky130_fd_sc_hd__fill_2
XFILLER_100_349 vssd1 vccd1 vssd1 vccd1 X2_sky130_ef_sc_hd__decap_40_12
XFILLER_27_617 vssd1 vccd1 vccd1 vssd1 X2_sky130_fd_sc_hd__fill_8
XTAP_TAPCELL_ROW_1_226 vccd1 vssd1 X2_sky130_fd_sc_hd__tapvpwrvgnd_1
XTAP_TAPCELL_ROW_37_623 vccd1 vssd1 X2_sky130_fd_sc_hd__tapvpwrvgnd_1
XFILLER_66_285 vssd1 vccd1 vccd1 vssd1 X2_sky130_fd_sc_hd__fill_2
XTAP_TAPCELL_ROW_65_932 vccd1 vssd1 X2_sky130_fd_sc_hd__tapvpwrvgnd_1
XFILLER_25_39 vssd1 vccd1 vssd1 vccd1 X2_sky130_ef_sc_hd__decap_40_12
XFILLER_81_277 vssd1 vccd1 vccd1 vssd1 X2_sky130_fd_sc_hd__fill_2
XFILLER_22_333 vssd1 vccd1 vssd1 vccd1 X2_sky130_ef_sc_hd__decap_40_12
XFILLER_34_193 vssd1 vccd1 vccd1 vssd1 X2_sky130_fd_sc_hd__fill_2
XFILLER_22_377 vssd1 vccd1 vssd1 vccd1 X2_sky130_ef_sc_hd__decap_40_12
XFILLER_41_27 vssd1 vccd1 vssd1 vccd1 X2_sky130_ef_sc_hd__decap_40_12
XTAP_TAPCELL_ROW_9_315 vccd1 vssd1 X2_sky130_fd_sc_hd__tapvpwrvgnd_1
XFILLER_1_237 vssd1 vccd1 vssd1 vccd1 X2_sky130_ef_sc_hd__decap_40_12
XFILLER_89_333 vssd1 vccd1 vccd1 vssd1 X2_sky130_fd_sc_hd__fill_2
XFILLER_77_517 vssd1 vccd1 vssd1 vccd1 X2_sky130_ef_sc_hd__decap_40_12
XFILLER_85_561 vssd1 vccd1 vssd1 vccd1 X2_sky130_ef_sc_hd__decap_40_12
XFILLER_17_105 vssd1 vccd1 vccd1 vssd1 X2_sky130_fd_sc_hd__fill_4
XFILLER_57_285 vccd1 vssd1 vccd1 vssd1 X2_sky130_fd_sc_hd__fill_1
XFILLER_45_425 vccd1 vssd1 vccd1 vssd1 X2_sky130_fd_sc_hd__fill_1
XFILLER_17_149 vssd1 vccd1 vssd1 vccd1 X2_sky130_ef_sc_hd__decap_40_12
X_521_ vccd1 vssd1 vccd1 vssd1 _521_/Y _521_/A X2_sky130_fd_sc_hd__inv_2
XFILLER_72_233 vssd1 vccd1 vssd1 vccd1 X2_sky130_ef_sc_hd__decap_40_12
XFILLER_45_447 vccd1 vssd1 vccd1 vssd1 X2_sky130_fd_sc_hd__fill_1
X_452_ vccd1 vssd1 vccd1 vssd1 _452_/Y _473_/A X2_sky130_fd_sc_hd__inv_2
XFILLER_72_277 vssd1 vccd1 vssd1 vccd1 X2_sky130_ef_sc_hd__decap_40_12
XFILLER_60_417 vssd1 vccd1 vccd1 vssd1 X2_sky130_fd_sc_hd__fill_2
XFILLER_13_333 vssd1 vccd1 vccd1 vssd1 X2_sky130_fd_sc_hd__fill_2
XFILLER_25_193 vssd1 vccd1 vssd1 vccd1 X2_sky130_ef_sc_hd__decap_40_12
X_383_ vccd1 vssd1 vssd1 vccd1 _536_/Q _551_/Q _414_/A X2_sky130_fd_sc_hd__nand2b_1
XFILLER_40_141 vssd1 vccd1 vssd1 vccd1 X2_sky130_ef_sc_hd__decap_40_12
XFILLER_9_337 vssd1 vccd1 vssd1 vccd1 X2_sky130_ef_sc_hd__decap_40_12
XFILLER_31_93 vssd1 vccd1 vssd1 vccd1 X2_sky130_ef_sc_hd__decap_40_12
XFILLER_0_281 vssd1 vccd1 vccd1 vssd1 X2_sky130_fd_sc_hd__fill_2
XFILLER_36_425 vssd1 vccd1 vccd1 vssd1 X2_sky130_fd_sc_hd__fill_2
XFILLER_36_447 vssd1 vccd1 vccd1 vssd1 X2_sky130_fd_sc_hd__fill_2
XFILLER_91_553 vssd1 vccd1 vccd1 vssd1 X2_sky130_fd_sc_hd__fill_4
XFILLER_63_222 vssd1 vccd1 vccd1 vssd1 X2_sky130_fd_sc_hd__fill_2
XFILLER_91_597 vssd1 vccd1 vssd1 vccd1 X2_sky130_ef_sc_hd__decap_40_12
XTAP_TAPCELL_ROW_62_902 vccd1 vssd1 X2_sky130_fd_sc_hd__tapvpwrvgnd_1
XFILLER_16_193 vssd1 vccd1 vccd1 vssd1 X2_sky130_fd_sc_hd__fill_2
XFILLER_32_620 vssd1 vccd1 vccd1 vssd1 X2_sky130_fd_sc_hd__fill_2
XFILLER_44_491 vssd1 vccd1 vccd1 vssd1 X2_sky130_fd_sc_hd__fill_2
XTAP_TAPCELL_ROW_14_372 vccd1 vssd1 X2_sky130_fd_sc_hd__tapvpwrvgnd_1
XTAP_TAPCELL_ROW_70_990 vccd1 vssd1 X2_sky130_fd_sc_hd__tapvpwrvgnd_1
XANTENNA__491__A _525_/A vssd1 vccd1 vccd1 vssd1 X2_sky130_fd_sc_hd__diode_2
XTAP_TAPCELL_ROW_42_681 vccd1 vssd1 X2_sky130_fd_sc_hd__tapvpwrvgnd_1
XFILLER_98_141 vssd1 vccd1 vssd1 vccd1 X2_sky130_ef_sc_hd__decap_40_12
XFILLER_59_517 vssd1 vccd1 vssd1 vccd1 X2_sky130_ef_sc_hd__decap_40_12
XFILLER_67_561 vssd1 vccd1 vssd1 vccd1 X2_sky130_ef_sc_hd__decap_40_12
XFILLER_36_27 vccd1 vssd1 vccd1 vssd1 X2_sky130_fd_sc_hd__fill_1
XFILLER_39_274 vssd1 vccd1 vccd1 vssd1 X2_sky130_fd_sc_hd__fill_4
XFILLER_15_609 vssd1 vccd1 vccd1 vssd1 X2_sky130_fd_sc_hd__fill_4
XFILLER_27_447 vccd1 vssd1 vccd1 vssd1 X2_sky130_fd_sc_hd__fill_1
XFILLER_82_531 vccd1 vssd1 vccd1 vssd1 X2_sky130_fd_sc_hd__fill_1
XFILLER_54_244 vssd1 vccd1 vccd1 vssd1 X2_sky130_fd_sc_hd__fill_8
XFILLER_54_299 vssd1 vccd1 vccd1 vssd1 X2_sky130_fd_sc_hd__fill_8
XFILLER_52_15 vssd1 vccd1 vssd1 vccd1 X2_sky130_ef_sc_hd__decap_40_12
XFILLER_22_141 vssd1 vccd1 vssd1 vccd1 X2_sky130_ef_sc_hd__decap_40_12
XFILLER_50_494 vssd1 vccd1 vssd1 vccd1 X2_sky130_ef_sc_hd__decap_40_12
XFILLER_6_307 vccd1 vssd1 vccd1 vssd1 X2_sky130_fd_sc_hd__fill_1
XFILLER_2_513 vssd1 vccd1 vssd1 vccd1 X2_sky130_ef_sc_hd__decap_40_12
XTAP_TAPCELL_ROW_75_1049 vccd1 vssd1 X2_sky130_fd_sc_hd__tapvpwrvgnd_1
XFILLER_2_557 vssd1 vccd1 vssd1 vccd1 X2_sky130_ef_sc_hd__decap_40_12
XFILLER_92_317 vssd1 vccd1 vccd1 vssd1 X2_sky130_fd_sc_hd__fill_2
XFILLER_92_328 vssd1 vccd1 vccd1 vssd1 X2_sky130_fd_sc_hd__fill_2
XFILLER_58_594 vccd1 vssd1 vccd1 vssd1 X2_sky130_fd_sc_hd__fill_1
XFILLER_45_200 vssd1 vccd1 vccd1 vssd1 X2_sky130_fd_sc_hd__fill_2
XFILLER_18_469 vssd1 vccd1 vccd1 vssd1 X2_sky130_fd_sc_hd__fill_4
XFILLER_93_55 vccd1 vssd1 vccd1 vssd1 X2_sky130_fd_sc_hd__fill_1
XFILLER_85_391 vccd1 vssd1 vccd1 vssd1 X2_sky130_fd_sc_hd__fill_1
XFILLER_73_553 vssd1 vccd1 vccd1 vssd1 X2_sky130_fd_sc_hd__fill_4
XFILLER_45_222 vssd1 vccd1 vccd1 vssd1 X2_sky130_fd_sc_hd__fill_2
XTAP_TAPCELL_ROW_86_1167 vccd1 vssd1 X2_sky130_fd_sc_hd__tapvpwrvgnd_1
X_504_ vccd1 vssd1 vccd1 vssd1 _504_/Y _527_/A X2_sky130_fd_sc_hd__inv_2
XFILLER_45_277 vssd1 vccd1 vccd1 vssd1 X2_sky130_fd_sc_hd__fill_2
X_435_ vccd1 vssd1 vssd1 vccd1 _424_/X _426_/Y _434_/Y _436_/B X2_sky130_fd_sc_hd__o21a_1
X_366_ vccd1 vssd1 vssd1 vccd1 hold4/A _548_/Q _368_/C X2_sky130_fd_sc_hd__nand2b_1
XFILLER_9_167 vccd1 vssd1 vccd1 vssd1 X2_sky130_fd_sc_hd__fill_1
X_297_ vssd1 vccd1 vccd1 vssd1 _576_/D hold77/X _299_/S _297_/A0 X2_sky130_fd_sc_hd__mux2_1
XTAP_TAPCELL_ROW_11_342 vccd1 vssd1 X2_sky130_fd_sc_hd__tapvpwrvgnd_1
XFILLER_42_81 vssd1 vccd1 vccd1 vssd1 X2_sky130_fd_sc_hd__fill_2
XFILLER_5_373 vssd1 vccd1 vssd1 vccd1 X2_sky130_ef_sc_hd__decap_40_12
XTAP_TAPCELL_ROW_97_1285 vccd1 vssd1 X2_sky130_fd_sc_hd__tapvpwrvgnd_1
XFILLER_96_601 vssd1 vccd1 vssd1 vccd1 X2_sky130_ef_sc_hd__decap_40_12
XFILLER_95_111 vccd1 vssd1 vccd1 vssd1 X2_sky130_fd_sc_hd__fill_1
XFILLER_49_561 vccd1 vssd1 vccd1 vssd1 X2_sky130_fd_sc_hd__fill_1
XFILLER_83_317 vssd1 vccd1 vssd1 vccd1 X2_sky130_ef_sc_hd__decap_40_12
XTAP_TAPCELL_ROW_19_431 vccd1 vssd1 X2_sky130_fd_sc_hd__tapvpwrvgnd_1
XFILLER_36_233 vssd1 vccd1 vccd1 vssd1 X2_sky130_fd_sc_hd__fill_2
XANTENNA__486__A _521_/A vssd1 vccd1 vccd1 vssd1 X2_sky130_fd_sc_hd__diode_2
XTAP_TAPCELL_ROW_47_740 vccd1 vssd1 X2_sky130_fd_sc_hd__tapvpwrvgnd_1
XFILLER_24_417 vssd1 vccd1 vccd1 vssd1 X2_sky130_fd_sc_hd__fill_2
XFILLER_51_203 vssd1 vccd1 vssd1 vccd1 X2_sky130_ef_sc_hd__decap_40_12
XFILLER_51_225 vccd1 vssd1 vccd1 vssd1 X2_sky130_fd_sc_hd__fill_1
XFILLER_20_601 vssd1 vccd1 vssd1 vccd1 X2_sky130_ef_sc_hd__decap_40_12
XFILLER_22_29 vssd1 vccd1 vssd1 vccd1 X2_sky130_ef_sc_hd__decap_40_12
XANTENNA__335__B2 _547_/D vssd1 vccd1 vccd1 vssd1 X2_sky130_fd_sc_hd__diode_2
XANTENNA__592__CLK _607_/CLK vssd1 vccd1 vccd1 vssd1 X2_sky130_fd_sc_hd__diode_2
XFILLER_99_461 vssd1 vccd1 vssd1 vccd1 X2_sky130_ef_sc_hd__decap_40_12
XFILLER_59_314 vssd1 vccd1 vssd1 vccd1 X2_sky130_ef_sc_hd__decap_40_12
XANTENNA_input1_A adc_data_in[0] vssd1 vccd1 vccd1 vssd1 X2_sky130_fd_sc_hd__diode_2
XFILLER_86_133 vssd1 vccd1 vccd1 vssd1 X2_sky130_fd_sc_hd__fill_4
XFILLER_101_477 vssd1 vccd1 vssd1 vccd1 X2_sky130_ef_sc_hd__decap_40_12
XFILLER_86_177 vssd1 vccd1 vssd1 vccd1 X2_sky130_ef_sc_hd__decap_40_12
XFILLER_67_391 vccd1 vssd1 vccd1 vssd1 X2_sky130_fd_sc_hd__fill_1
XFILLER_55_553 vssd1 vccd1 vccd1 vssd1 X2_sky130_fd_sc_hd__fill_4
XFILLER_15_417 vssd1 vccd1 vssd1 vccd1 X2_sky130_ef_sc_hd__decap_40_12
XFILLER_27_277 vssd1 vccd1 vccd1 vssd1 X2_sky130_fd_sc_hd__fill_2
XFILLER_82_361 vssd1 vccd1 vccd1 vssd1 X2_sky130_fd_sc_hd__fill_2
XFILLER_70_501 vssd1 vccd1 vssd1 vccd1 X2_sky130_ef_sc_hd__decap_40_12
XFILLER_70_545 vssd1 vccd1 vssd1 vccd1 X2_sky130_ef_sc_hd__decap_40_12
XFILLER_42_236 vssd1 vccd1 vccd1 vssd1 X2_sky130_fd_sc_hd__fill_2
XFILLER_63_69 vssd1 vccd1 vssd1 vccd1 X2_sky130_ef_sc_hd__decap_40_12
XFILLER_23_461 vssd1 vccd1 vssd1 vccd1 X2_sky130_ef_sc_hd__decap_40_12
XFILLER_70_589 vccd1 vssd1 vccd1 vssd1 X2_sky130_fd_sc_hd__fill_1
XTAP_TAPCELL_ROW_53_798 vccd1 vssd1 X2_sky130_fd_sc_hd__tapvpwrvgnd_1
XFILLER_10_133 vssd1 vccd1 vccd1 vssd1 X2_sky130_fd_sc_hd__fill_4
XFILLER_10_177 vssd1 vccd1 vssd1 vccd1 X2_sky130_ef_sc_hd__decap_40_12
XFILLER_6_137 vssd1 vccd1 vccd1 vssd1 X2_sky130_fd_sc_hd__fill_2
XFILLER_2_321 vssd1 vccd1 vssd1 vccd1 X2_sky130_ef_sc_hd__decap_40_12
XFILLER_2_365 vssd1 vccd1 vssd1 vccd1 X2_sky130_ef_sc_hd__decap_40_12
XFILLER_88_77 vssd1 vccd1 vccd1 vssd1 X2_sky130_fd_sc_hd__fill_4
XFILLER_97_409 vssd1 vccd1 vccd1 vssd1 X2_sky130_fd_sc_hd__fill_2
XFILLER_78_601 vssd1 vccd1 vssd1 vccd1 X2_sky130_ef_sc_hd__decap_40_12
XFILLER_77_111 vccd1 vssd1 vccd1 vssd1 X2_sky130_fd_sc_hd__fill_1
Xtop_soc_68 wbs_dat_o[16] top_soc_68/HI vccd1 vssd1 vssd1 vccd1 X2_sky130_fd_sc_hd__conb_1
Xtop_soc_79 wbs_dat_o[27] top_soc_79/HI vccd1 vssd1 vssd1 vccd1 X2_sky130_fd_sc_hd__conb_1
XFILLER_93_615 vccd1 vssd1 vccd1 vssd1 X2_sky130_fd_sc_hd__fill_1
XFILLER_65_317 vssd1 vccd1 vssd1 vccd1 X2_sky130_ef_sc_hd__decap_40_12
XFILLER_18_233 vssd1 vccd1 vssd1 vccd1 X2_sky130_ef_sc_hd__decap_40_12
XFILLER_46_531 vccd1 vssd1 vccd1 vssd1 X2_sky130_fd_sc_hd__fill_1
XFILLER_18_277 vssd1 vccd1 vssd1 vccd1 X2_sky130_ef_sc_hd__decap_40_12
XFILLER_37_81 vssd1 vccd1 vssd1 vccd1 X2_sky130_ef_sc_hd__decap_40_12
XFILLER_80_309 vssd1 vccd1 vssd1 vccd1 X2_sky130_ef_sc_hd__decap_40_12
XFILLER_73_361 vssd1 vccd1 vssd1 vccd1 X2_sky130_ef_sc_hd__decap_40_12
XFILLER_61_501 vssd1 vccd1 vccd1 vssd1 X2_sky130_fd_sc_hd__fill_2
XTAP_TAPCELL_ROW_16_401 vccd1 vssd1 X2_sky130_fd_sc_hd__tapvpwrvgnd_1
XFILLER_33_225 vssd1 vccd1 vccd1 vssd1 X2_sky130_fd_sc_hd__fill_2
XFILLER_33_236 vssd1 vccd1 vccd1 vssd1 X2_sky130_fd_sc_hd__fill_4
XFILLER_46_597 vssd1 vccd1 vccd1 vssd1 X2_sky130_fd_sc_hd__fill_2
X_418_ vssd1 vccd1 vssd1 vccd1 _418_/X _420_/A _406_/C _416_/Y _417_/X X2_sky130_fd_sc_hd__o211a_1
XFILLER_41_291 vccd1 vssd1 vccd1 vssd1 X2_sky130_fd_sc_hd__fill_1
XTAP_TAPCELL_ROW_99_1314 vccd1 vssd1 X2_sky130_fd_sc_hd__tapvpwrvgnd_1
X_349_ vccd1 vssd1 vssd1 vccd1 _356_/A _555_/Q _405_/A X2_sky130_fd_sc_hd__nor2_1
XFILLER_52_3 vssd1 vccd1 vssd1 vccd1 X2_sky130_ef_sc_hd__decap_40_12
XFILLER_5_181 vssd1 vccd1 vssd1 vccd1 X2_sky130_ef_sc_hd__decap_40_12
XFILLER_68_133 vssd1 vccd1 vccd1 vssd1 X2_sky130_fd_sc_hd__fill_4
XFILLER_96_475 vccd1 vssd1 vccd1 vssd1 X2_sky130_fd_sc_hd__fill_1
XFILLER_68_177 vssd1 vccd1 vssd1 vccd1 X2_sky130_ef_sc_hd__decap_40_12
XFILLER_56_328 vssd1 vccd1 vccd1 vssd1 X2_sky130_fd_sc_hd__fill_4
XFILLER_83_125 vssd1 vccd1 vssd1 vccd1 X2_sky130_ef_sc_hd__decap_40_12
XFILLER_49_380 vssd1 vccd1 vssd1 vccd1 X2_sky130_ef_sc_hd__decap_40_12
XFILLER_37_575 vssd1 vccd1 vccd1 vssd1 X2_sky130_fd_sc_hd__fill_2
XFILLER_83_169 vssd1 vccd1 vssd1 vccd1 X2_sky130_ef_sc_hd__decap_40_12
XFILLER_52_545 vssd1 vccd1 vccd1 vssd1 X2_sky130_fd_sc_hd__fill_8
XFILLER_33_39 vssd1 vccd1 vssd1 vccd1 X2_sky130_ef_sc_hd__decap_40_12
XFILLER_52_589 vssd1 vccd1 vssd1 vccd1 X2_sky130_ef_sc_hd__decap_40_12
XTAP_TAPCELL_ROW_22_459 vccd1 vssd1 X2_sky130_fd_sc_hd__tapvpwrvgnd_1
XFILLER_20_475 vccd1 vssd1 vccd1 vssd1 X2_sky130_fd_sc_hd__fill_1
XTAP_TAPCELL_ROW_50_768 vccd1 vssd1 X2_sky130_fd_sc_hd__tapvpwrvgnd_1
XTAP_TAPCELL_ROW_72_1008 vccd1 vssd1 X2_sky130_fd_sc_hd__tapvpwrvgnd_1
XFILLER_59_111 vccd1 vssd1 vccd1 vssd1 X2_sky130_fd_sc_hd__fill_1
XFILLER_87_497 vssd1 vccd1 vccd1 vssd1 X2_sky130_fd_sc_hd__fill_4
XFILLER_75_615 vccd1 vssd1 vccd1 vssd1 X2_sky130_fd_sc_hd__fill_1
XFILLER_47_317 vssd1 vccd1 vccd1 vssd1 X2_sky130_fd_sc_hd__fill_2
XFILLER_28_531 vccd1 vssd1 vccd1 vssd1 X2_sky130_fd_sc_hd__fill_1
XTAP_TAPCELL_ROW_58_857 vccd1 vssd1 X2_sky130_fd_sc_hd__tapvpwrvgnd_1
XFILLER_62_309 vssd1 vccd1 vssd1 vccd1 X2_sky130_ef_sc_hd__decap_40_12
XFILLER_55_361 vssd1 vccd1 vssd1 vccd1 X2_sky130_ef_sc_hd__decap_40_12
XFILLER_15_225 vssd1 vccd1 vssd1 vccd1 X2_sky130_ef_sc_hd__decap_40_12
XTAP_TAPCELL_ROW_83_1137 vccd1 vssd1 X2_sky130_fd_sc_hd__tapvpwrvgnd_1
XFILLER_11_497 vssd1 vccd1 vccd1 vssd1 X2_sky130_fd_sc_hd__fill_4
XTAP_TAPCELL_ROW_94_1255 vccd1 vssd1 X2_sky130_fd_sc_hd__tapvpwrvgnd_1
XFILLER_97_217 vssd1 vccd1 vccd1 vssd1 X2_sky130_fd_sc_hd__fill_4
XFILLER_2_195 vccd1 vssd1 vccd1 vssd1 X2_sky130_fd_sc_hd__fill_1
XFILLER_66_604 vssd1 vccd1 vccd1 vssd1 X2_sky130_fd_sc_hd__fill_2
XFILLER_38_328 vssd1 vccd1 vssd1 vccd1 X2_sky130_ef_sc_hd__decap_40_12
XFILLER_78_475 vccd1 vssd1 vccd1 vssd1 X2_sky130_fd_sc_hd__fill_1
XFILLER_93_445 vssd1 vccd1 vccd1 vssd1 X2_sky130_fd_sc_hd__fill_2
XFILLER_65_125 vssd1 vccd1 vssd1 vccd1 X2_sky130_ef_sc_hd__decap_40_12
XFILLER_19_553 vssd1 vccd1 vccd1 vssd1 X2_sky130_fd_sc_hd__fill_4
XFILLER_65_169 vssd1 vccd1 vssd1 vccd1 X2_sky130_ef_sc_hd__decap_40_12
XFILLER_19_597 vssd1 vccd1 vssd1 vccd1 X2_sky130_ef_sc_hd__decap_40_12
XFILLER_80_139 vccd1 vssd1 vccd1 vssd1 X2_sky130_fd_sc_hd__fill_1
XANTENNA__537__Q _537_/Q vssd1 vccd1 vccd1 vssd1 X2_sky130_fd_sc_hd__diode_2
XFILLER_34_545 vssd1 vccd1 vccd1 vssd1 X2_sky130_fd_sc_hd__fill_4
XFILLER_21_217 vssd1 vccd1 vccd1 vssd1 X2_sky130_fd_sc_hd__fill_4
XFILLER_34_589 vssd1 vccd1 vccd1 vssd1 X2_sky130_fd_sc_hd__fill_4
XFILLER_61_364 vssd1 vccd1 vssd1 vccd1 X2_sky130_ef_sc_hd__decap_40_12
XANTENNA_hold20_X _553_/D vssd1 vccd1 vccd1 vssd1 X2_sky130_fd_sc_hd__diode_2
XFILLER_84_401 vssd1 vccd1 vssd1 vccd1 X2_sky130_ef_sc_hd__decap_40_12
XFILLER_84_445 vssd1 vccd1 vssd1 vccd1 X2_sky130_ef_sc_hd__decap_40_12
XFILLER_69_497 vssd1 vccd1 vccd1 vssd1 X2_sky130_fd_sc_hd__fill_4
XFILLER_25_501 vssd1 vccd1 vccd1 vssd1 X2_sky130_fd_sc_hd__fill_2
XFILLER_37_350 vssd1 vccd1 vccd1 vssd1 X2_sky130_fd_sc_hd__fill_2
XFILLER_84_489 vssd1 vccd1 vssd1 vccd1 X2_sky130_ef_sc_hd__decap_40_12
XFILLER_44_309 vssd1 vccd1 vssd1 vccd1 X2_sky130_ef_sc_hd__decap_40_12
XTAP_TAPCELL_ROW_27_518 vccd1 vssd1 X2_sky130_fd_sc_hd__tapvpwrvgnd_1
XFILLER_37_383 vssd1 vccd1 vccd1 vssd1 X2_sky130_fd_sc_hd__fill_2
XTAP_TAPCELL_ROW_55_827 vccd1 vssd1 X2_sky130_fd_sc_hd__tapvpwrvgnd_1
XFILLER_52_331 vssd1 vccd1 vccd1 vssd1 X2_sky130_fd_sc_hd__fill_4
XFILLER_44_27 vccd1 vssd1 vccd1 vssd1 X2_sky130_fd_sc_hd__fill_1
XFILLER_100_77 vssd1 vccd1 vccd1 vssd1 X2_sky130_fd_sc_hd__fill_4
XFILLER_60_15 vssd1 vccd1 vssd1 vccd1 X2_sky130_ef_sc_hd__decap_40_12
XFILLER_69_57 vssd1 vccd1 vssd1 vccd1 X2_sky130_ef_sc_hd__decap_40_12
XFILLER_79_217 vssd1 vccd1 vccd1 vssd1 X2_sky130_fd_sc_hd__fill_4
XTAP_TAPCELL_ROW_7_298 vccd1 vssd1 X2_sky130_fd_sc_hd__tapvpwrvgnd_1
XFILLER_87_261 vssd1 vccd1 vssd1 vccd1 X2_sky130_ef_sc_hd__decap_40_12
XFILLER_94_209 vssd1 vccd1 vssd1 vccd1 X2_sky130_ef_sc_hd__decap_40_12
XANTENNA_fanout62_X _521_/A vssd1 vccd1 vccd1 vssd1 X2_sky130_fd_sc_hd__diode_2
XFILLER_75_445 vssd1 vccd1 vccd1 vssd1 X2_sky130_fd_sc_hd__fill_2
XFILLER_47_125 vssd1 vccd1 vssd1 vccd1 X2_sky130_ef_sc_hd__decap_40_12
XFILLER_47_169 vccd1 vssd1 vccd1 vssd1 X2_sky130_fd_sc_hd__fill_1
XFILLER_16_501 vssd1 vccd1 vssd1 vccd1 X2_sky130_ef_sc_hd__decap_40_12
XFILLER_18_83 vccd1 vssd1 vccd1 vssd1 X2_sky130_fd_sc_hd__fill_1
XFILLER_28_361 vssd1 vccd1 vccd1 vssd1 X2_sky130_fd_sc_hd__fill_2
XFILLER_62_139 vccd1 vssd1 vccd1 vssd1 X2_sky130_fd_sc_hd__fill_1
XFILLER_16_545 vssd1 vccd1 vssd1 vccd1 X2_sky130_ef_sc_hd__decap_40_12
XFILLER_43_353 vccd1 vssd1 vccd1 vssd1 X2_sky130_fd_sc_hd__fill_1
XFILLER_16_589 vssd1 vccd1 vssd1 vccd1 X2_sky130_ef_sc_hd__decap_40_12
XFILLER_31_559 vccd1 vssd1 vccd1 vssd1 X2_sky130_fd_sc_hd__fill_1
XFILLER_7_221 vssd1 vccd1 vccd1 vssd1 X2_sky130_fd_sc_hd__fill_2
XFILLER_11_261 vssd1 vccd1 vssd1 vccd1 X2_sky130_ef_sc_hd__decap_40_12
XFILLER_50_81 vssd1 vccd1 vccd1 vssd1 X2_sky130_fd_sc_hd__fill_2
XFILLER_39_615 vccd1 vssd1 vccd1 vssd1 X2_sky130_fd_sc_hd__fill_1
XFILLER_66_401 vssd1 vccd1 vssd1 vccd1 X2_sky130_ef_sc_hd__decap_40_12
XFILLER_15_3 vssd1 vccd1 vssd1 vccd1 X2_sky130_ef_sc_hd__decap_40_12
XFILLER_66_445 vssd1 vccd1 vssd1 vccd1 X2_sky130_ef_sc_hd__decap_40_12
XFILLER_26_309 vssd1 vccd1 vssd1 vccd1 X2_sky130_ef_sc_hd__decap_40_12
XFILLER_93_253 vssd1 vccd1 vccd1 vssd1 X2_sky130_fd_sc_hd__fill_2
XFILLER_19_361 vssd1 vccd1 vssd1 vccd1 X2_sky130_ef_sc_hd__decap_40_12
XFILLER_66_489 vssd1 vccd1 vssd1 vccd1 X2_sky130_ef_sc_hd__decap_40_12
XANTENNA__494__A _517_/A vssd1 vccd1 vccd1 vssd1 X2_sky130_fd_sc_hd__diode_2
XFILLER_61_161 vssd1 vccd1 vccd1 vssd1 X2_sky130_fd_sc_hd__fill_4
XFILLER_30_581 vssd1 vccd1 vccd1 vssd1 X2_sky130_fd_sc_hd__fill_4
XTAP_TAPCELL_ROW_32_576 vccd1 vssd1 X2_sky130_fd_sc_hd__tapvpwrvgnd_1
XTAP_TAPCELL_ROW_60_885 vccd1 vssd1 X2_sky130_fd_sc_hd__tapvpwrvgnd_1
XFILLER_30_29 vssd1 vccd1 vssd1 vccd1 X2_sky130_ef_sc_hd__decap_40_12
XFILLER_89_559 vccd1 vssd1 vccd1 vssd1 X2_sky130_fd_sc_hd__fill_1
XFILLER_76_209 vssd1 vccd1 vssd1 vccd1 X2_sky130_ef_sc_hd__decap_40_12
XFILLER_69_261 vssd1 vccd1 vssd1 vccd1 X2_sky130_ef_sc_hd__decap_40_12
XFILLER_29_125 vssd1 vccd1 vssd1 vccd1 X2_sky130_ef_sc_hd__decap_40_12
XFILLER_57_445 vssd1 vccd1 vccd1 vssd1 X2_sky130_fd_sc_hd__fill_2
XANTENNA__388__B _537_/Q vssd1 vccd1 vccd1 vssd1 X2_sky130_fd_sc_hd__diode_2
XTAP_TAPCELL_ROW_4_268 vccd1 vssd1 X2_sky130_fd_sc_hd__tapvpwrvgnd_1
XFILLER_29_169 vssd1 vccd1 vssd1 vccd1 X2_sky130_ef_sc_hd__decap_40_12
XFILLER_84_253 vssd1 vccd1 vssd1 vccd1 X2_sky130_ef_sc_hd__decap_40_12
XTAP_TAPCELL_ROW_68_963 vccd1 vssd1 X2_sky130_fd_sc_hd__tapvpwrvgnd_1
XFILLER_55_15 vssd1 vccd1 vssd1 vccd1 X2_sky130_ef_sc_hd__decap_40_12
XFILLER_44_139 vccd1 vssd1 vccd1 vssd1 X2_sky130_fd_sc_hd__fill_1
XFILLER_13_559 vccd1 vssd1 vccd1 vssd1 X2_sky130_fd_sc_hd__fill_1
XFILLER_71_69 vssd1 vccd1 vssd1 vccd1 X2_sky130_ef_sc_hd__decap_40_12
XTAP_TAPCELL_ROW_91_1225 vccd1 vssd1 X2_sky130_fd_sc_hd__tapvpwrvgnd_1
XFILLER_95_529 vssd1 vccd1 vssd1 vccd1 X2_sky130_ef_sc_hd__decap_40_12
XFILLER_96_77 vssd1 vccd1 vccd1 vssd1 X2_sky130_fd_sc_hd__fill_4
XFILLER_88_581 vssd1 vccd1 vccd1 vssd1 X2_sky130_fd_sc_hd__fill_4
XFILLER_48_412 vssd1 vccd1 vccd1 vssd1 X2_sky130_fd_sc_hd__fill_2
XFILLER_29_93 vssd1 vccd1 vssd1 vccd1 X2_sky130_ef_sc_hd__decap_40_12
Xhold60 _560_/D _334_/X vccd1 vssd1 vssd1 vccd1 X2_sky130_fd_sc_hd__dlygate4sd3_1
Xhold82 _436_/A _409_/X vccd1 vssd1 vssd1 vccd1 X2_sky130_fd_sc_hd__dlygate4sd3_1
XFILLER_48_467 vssd1 vccd1 vccd1 vssd1 X2_sky130_fd_sc_hd__fill_2
XFILLER_48_456 vssd1 vccd1 vccd1 vssd1 X2_sky130_fd_sc_hd__fill_2
Xhold71 hold71/X _581_/Q vccd1 vssd1 vssd1 vccd1 X2_sky130_fd_sc_hd__dlygate4sd3_1
XTAP_TAPCELL_ROW_89_1198 vccd1 vssd1 X2_sky130_fd_sc_hd__tapvpwrvgnd_1
XFILLER_90_245 vssd1 vccd1 vccd1 vssd1 X2_sky130_fd_sc_hd__fill_4
XFILLER_90_289 vssd1 vccd1 vccd1 vssd1 X2_sky130_fd_sc_hd__fill_2
XFILLER_50_109 vssd1 vccd1 vssd1 vccd1 X2_sky130_ef_sc_hd__decap_40_12
XFILLER_45_81 vssd1 vccd1 vssd1 vccd1 X2_sky130_ef_sc_hd__decap_40_12
XFILLER_43_161 vssd1 vccd1 vccd1 vssd1 X2_sky130_fd_sc_hd__fill_4
X_597_ vccd1 vssd1 vccd1 vssd1 _597_/Q _517_/Y _597_/D _597_/CLK X2_sky130_fd_sc_hd__dfstp_1
XFILLER_31_345 vssd1 vccd1 vccd1 vssd1 X2_sky130_fd_sc_hd__fill_2
XTAP_TAPCELL_ROW_100_1321 vccd1 vssd1 X2_sky130_fd_sc_hd__tapvpwrvgnd_1
XFILLER_12_581 vssd1 vccd1 vccd1 vssd1 X2_sky130_fd_sc_hd__fill_4
XANTENNA_clkbuf_3_7__f_wb_clk_i_X _606_/CLK vssd1 vccd1 vccd1 vssd1 X2_sky130_fd_sc_hd__diode_2
XFILLER_8_585 vssd1 vccd1 vccd1 vssd1 X2_sky130_fd_sc_hd__fill_2
XANTENNA_2 _536_/D vssd1 vccd1 vccd1 vssd1 X2_sky130_fd_sc_hd__diode_2
XFILLER_6_53 vssd1 vccd1 vssd1 vccd1 X2_sky130_ef_sc_hd__decap_40_12
XFILLER_6_97 vssd1 vccd1 vssd1 vccd1 X2_sky130_ef_sc_hd__decap_40_12
XFILLER_98_312 vssd1 vccd1 vccd1 vssd1 X2_sky130_fd_sc_hd__fill_8
XFILLER_98_345 vssd1 vccd1 vssd1 vccd1 X2_sky130_ef_sc_hd__decap_40_12
XANTENNA__489__A _525_/A vssd1 vccd1 vccd1 vssd1 X2_sky130_fd_sc_hd__diode_2
XFILLER_86_529 vssd1 vccd1 vccd1 vssd1 X2_sky130_fd_sc_hd__fill_2
XFILLER_98_367 vccd1 vssd1 vccd1 vssd1 X2_sky130_fd_sc_hd__fill_1
XFILLER_98_389 vssd1 vccd1 vccd1 vssd1 X2_sky130_fd_sc_hd__fill_4
XFILLER_58_209 vssd1 vccd1 vssd1 vccd1 X2_sky130_ef_sc_hd__decap_40_12
XFILLER_39_445 vssd1 vccd1 vccd1 vssd1 X2_sky130_fd_sc_hd__fill_2
XFILLER_66_253 vssd1 vccd1 vssd1 vccd1 X2_sky130_ef_sc_hd__decap_40_12
XTAP_TAPCELL_ROW_1_227 vccd1 vssd1 X2_sky130_fd_sc_hd__tapvpwrvgnd_1
XTAP_TAPCELL_ROW_37_624 vccd1 vssd1 X2_sky130_fd_sc_hd__tapvpwrvgnd_1
XTAP_TAPCELL_ROW_65_933 vccd1 vssd1 X2_sky130_fd_sc_hd__tapvpwrvgnd_1
XFILLER_26_139 vccd1 vssd1 vccd1 vssd1 X2_sky130_fd_sc_hd__fill_1
XFILLER_81_223 vccd1 vssd1 vccd1 vssd1 X2_sky130_fd_sc_hd__fill_1
XFILLER_22_301 vssd1 vccd1 vccd1 vssd1 X2_sky130_fd_sc_hd__fill_4
XFILLER_41_109 vssd1 vccd1 vccd1 vssd1 X2_sky130_fd_sc_hd__fill_2
XFILLER_22_345 vssd1 vccd1 vssd1 vccd1 X2_sky130_ef_sc_hd__decap_40_12
XFILLER_10_529 vssd1 vccd1 vccd1 vssd1 X2_sky130_fd_sc_hd__fill_2
XFILLER_22_389 vssd1 vccd1 vssd1 vccd1 X2_sky130_ef_sc_hd__decap_40_12
XFILLER_41_39 vssd1 vccd1 vssd1 vccd1 X2_sky130_ef_sc_hd__decap_40_12
XTAP_TAPCELL_ROW_9_316 vccd1 vssd1 X2_sky130_fd_sc_hd__tapvpwrvgnd_1
XFILLER_1_205 vssd1 vccd1 vssd1 vccd1 X2_sky130_ef_sc_hd__decap_40_12
XFILLER_89_301 vssd1 vccd1 vccd1 vssd1 X2_sky130_fd_sc_hd__fill_4
XFILLER_1_249 vssd1 vccd1 vssd1 vccd1 X2_sky130_ef_sc_hd__decap_40_12
XFILLER_89_389 vssd1 vccd1 vccd1 vssd1 X2_sky130_fd_sc_hd__fill_2
XFILLER_77_529 vssd1 vccd1 vssd1 vccd1 X2_sky130_ef_sc_hd__decap_40_12
XFILLER_85_573 vssd1 vccd1 vssd1 vccd1 X2_sky130_ef_sc_hd__decap_40_12
X_520_ vccd1 vssd1 vccd1 vssd1 _520_/Y _521_/A X2_sky130_fd_sc_hd__inv_2
XFILLER_72_245 vssd1 vccd1 vccd1 vssd1 X2_sky130_fd_sc_hd__fill_4
X_451_ vccd1 vssd1 vccd1 vssd1 _451_/Y _473_/A X2_sky130_fd_sc_hd__inv_2
XFILLER_32_109 vssd1 vccd1 vssd1 vccd1 X2_sky130_ef_sc_hd__decap_40_12
XFILLER_72_289 vssd1 vccd1 vssd1 vccd1 X2_sky130_ef_sc_hd__decap_40_12
XFILLER_25_161 vssd1 vccd1 vccd1 vssd1 X2_sky130_fd_sc_hd__fill_4
XFILLER_53_470 vssd1 vccd1 vccd1 vssd1 X2_sky130_fd_sc_hd__fill_4
X_382_ vccd1 vssd1 vssd1 vccd1 _551_/Q _536_/Q _390_/A X2_sky130_fd_sc_hd__nand2b_1
XFILLER_9_305 vssd1 vccd1 vssd1 vccd1 X2_sky130_ef_sc_hd__decap_40_12
XFILLER_15_51 vssd1 vccd1 vccd1 vssd1 X2_sky130_fd_sc_hd__fill_4
XFILLER_40_153 vssd1 vccd1 vssd1 vccd1 X2_sky130_ef_sc_hd__decap_40_12
XFILLER_9_349 vssd1 vccd1 vssd1 vccd1 X2_sky130_ef_sc_hd__decap_40_12
XFILLER_13_389 vssd1 vccd1 vccd1 vssd1 X2_sky130_fd_sc_hd__fill_2
XFILLER_40_197 vccd1 vssd1 vccd1 vssd1 X2_sky130_fd_sc_hd__fill_1
XFILLER_99_109 vssd1 vccd1 vccd1 vssd1 X2_sky130_fd_sc_hd__fill_2
Xoutput50 vccd1 vssd1 wbs_dat_o[1] _558_/Q vccd1 vssd1 X2_sky130_fd_sc_hd__buf_2
XFILLER_68_529 vssd1 vccd1 vccd1 vssd1 X2_sky130_fd_sc_hd__fill_2
XFILLER_95_337 vccd1 vssd1 vccd1 vssd1 X2_sky130_fd_sc_hd__fill_1
XFILLER_48_253 vssd1 vccd1 vssd1 vccd1 X2_sky130_ef_sc_hd__decap_40_12
XFILLER_48_286 vssd1 vccd1 vssd1 vccd1 X2_sky130_ef_sc_hd__decap_40_12
XFILLER_36_437 vssd1 vccd1 vccd1 vssd1 X2_sky130_fd_sc_hd__fill_2
XFILLER_23_109 vssd1 vccd1 vccd1 vssd1 X2_sky130_fd_sc_hd__fill_2
XFILLER_63_289 vssd1 vccd1 vssd1 vccd1 X2_sky130_ef_sc_hd__decap_40_12
XTAP_TAPCELL_ROW_62_903 vccd1 vssd1 X2_sky130_fd_sc_hd__tapvpwrvgnd_1
XFILLER_51_407 vssd1 vccd1 vssd1 vccd1 X2_sky130_ef_sc_hd__decap_40_12
XTAP_TAPCELL_ROW_14_373 vccd1 vssd1 X2_sky130_fd_sc_hd__tapvpwrvgnd_1
XFILLER_82_3 vssd1 vccd1 vssd1 vccd1 X2_sky130_ef_sc_hd__decap_40_12
XTAP_TAPCELL_ROW_70_991 vccd1 vssd1 X2_sky130_fd_sc_hd__tapvpwrvgnd_1
XTAP_TAPCELL_ROW_42_682 vccd1 vssd1 X2_sky130_fd_sc_hd__tapvpwrvgnd_1
XFILLER_98_153 vssd1 vccd1 vssd1 vccd1 X2_sky130_ef_sc_hd__decap_40_12
XFILLER_101_615 vccd1 vssd1 vccd1 vssd1 X2_sky130_fd_sc_hd__fill_1
XFILLER_59_529 vssd1 vccd1 vssd1 vccd1 X2_sky130_ef_sc_hd__decap_40_12
XFILLER_98_197 vssd1 vccd1 vssd1 vccd1 X2_sky130_ef_sc_hd__decap_40_12
XFILLER_67_573 vssd1 vccd1 vssd1 vccd1 X2_sky130_ef_sc_hd__decap_40_12
XFILLER_14_109 vssd1 vccd1 vssd1 vccd1 X2_sky130_ef_sc_hd__decap_40_12
XFILLER_82_587 vccd1 vssd1 vccd1 vssd1 X2_sky130_fd_sc_hd__fill_1
XFILLER_54_278 vccd1 vssd1 vccd1 vssd1 X2_sky130_fd_sc_hd__fill_1
XFILLER_42_418 vssd1 vccd1 vccd1 vssd1 X2_sky130_fd_sc_hd__fill_2
XFILLER_42_407 vssd1 vccd1 vccd1 vssd1 X2_sky130_fd_sc_hd__fill_2
XFILLER_52_27 vccd1 vssd1 vccd1 vssd1 X2_sky130_fd_sc_hd__fill_1
XFILLER_22_153 vssd1 vccd1 vssd1 vccd1 X2_sky130_ef_sc_hd__decap_40_12
XFILLER_22_197 vssd1 vccd1 vssd1 vccd1 X2_sky130_ef_sc_hd__decap_40_12
XFILLER_2_525 vssd1 vccd1 vccd1 vssd1 X2_sky130_fd_sc_hd__fill_4
XFILLER_2_569 vssd1 vccd1 vssd1 vccd1 X2_sky130_ef_sc_hd__decap_40_12
XFILLER_77_337 vssd1 vccd1 vssd1 vccd1 X2_sky130_ef_sc_hd__decap_40_12
XFILLER_77_57 vssd1 vccd1 vssd1 vccd1 X2_sky130_ef_sc_hd__decap_40_12
XFILLER_92_307 vccd1 vssd1 vccd1 vssd1 X2_sky130_fd_sc_hd__fill_1
XFILLER_58_584 vssd1 vccd1 vccd1 vssd1 X2_sky130_fd_sc_hd__fill_4
XTAP_TAPCELL_ROW_86_1168 vccd1 vssd1 X2_sky130_fd_sc_hd__tapvpwrvgnd_1
X_503_ vccd1 vssd1 vccd1 vssd1 _503_/Y _527_/A X2_sky130_fd_sc_hd__inv_2
XFILLER_26_83 vccd1 vssd1 vccd1 vssd1 X2_sky130_fd_sc_hd__fill_1
XFILLER_60_237 vssd1 vccd1 vccd1 vssd1 X2_sky130_fd_sc_hd__fill_2
X_434_ vccd1 vssd1 vssd1 vccd1 _434_/A _434_/B _434_/Y X2_sky130_fd_sc_hd__nor2_1
XFILLER_45_289 vssd1 vccd1 vssd1 vccd1 X2_sky130_ef_sc_hd__decap_40_12
XFILLER_9_113 vssd1 vccd1 vssd1 vccd1 X2_sky130_ef_sc_hd__decap_40_12
X_365_ vccd1 vssd1 vssd1 vccd1 _547_/Q _532_/Q _368_/B X2_sky130_fd_sc_hd__nand2b_1
X_296_ vssd1 vccd1 vccd1 vssd1 _577_/D hold76/X _299_/S _446_/A1 X2_sky130_fd_sc_hd__mux2_1
XANTENNA__329__C1 _303_/X vssd1 vccd1 vccd1 vssd1 X2_sky130_fd_sc_hd__diode_2
XTAP_TAPCELL_ROW_11_343 vccd1 vssd1 X2_sky130_fd_sc_hd__tapvpwrvgnd_1
XANTENNA__344__A2 _317_/B vssd1 vccd1 vccd1 vssd1 X2_sky130_fd_sc_hd__diode_2
XPHY_EDGE_ROW_39_Left_141 vccd1 vssd1 vccd1 vssd1 X2_sky130_fd_sc_hd__decap_3
XTAP_TAPCELL_ROW_97_1286 vccd1 vssd1 X2_sky130_fd_sc_hd__tapvpwrvgnd_1
XFILLER_5_385 vssd1 vccd1 vccd1 vssd1 X2_sky130_fd_sc_hd__fill_4
XFILLER_96_613 vssd1 vccd1 vssd1 vccd1 X2_sky130_ef_sc_hd__decap_40_12
XFILLER_95_167 vccd1 vssd1 vccd1 vssd1 X2_sky130_fd_sc_hd__fill_1
XFILLER_83_329 vssd1 vccd1 vccd1 vssd1 X2_sky130_fd_sc_hd__fill_4
XTAP_TAPCELL_ROW_19_432 vccd1 vssd1 X2_sky130_fd_sc_hd__tapvpwrvgnd_1
XPHY_EDGE_ROW_48_Left_150 vccd1 vssd1 vccd1 vssd1 X2_sky130_fd_sc_hd__decap_3
XTAP_TAPCELL_ROW_47_741 vccd1 vssd1 X2_sky130_fd_sc_hd__tapvpwrvgnd_1
XFILLER_36_245 vccd1 vssd1 vccd1 vssd1 X2_sky130_fd_sc_hd__fill_1
XFILLER_91_340 vssd1 vccd1 vssd1 vccd1 X2_sky130_ef_sc_hd__decap_40_12
XFILLER_64_587 vccd1 vssd1 vccd1 vssd1 X2_sky130_fd_sc_hd__fill_1
XFILLER_51_215 vssd1 vccd1 vccd1 vssd1 X2_sky130_fd_sc_hd__fill_8
XFILLER_32_440 vssd1 vccd1 vssd1 vccd1 X2_sky130_ef_sc_hd__decap_40_12
XFILLER_20_613 vssd1 vccd1 vssd1 vccd1 X2_sky130_ef_sc_hd__decap_40_12
XANTENNA__335__A2 _291_/B vssd1 vccd1 vccd1 vssd1 X2_sky130_fd_sc_hd__diode_2
XFILLER_87_613 vssd1 vccd1 vccd1 vssd1 X2_sky130_fd_sc_hd__fill_2
XFILLER_101_401 vccd1 vssd1 vccd1 vssd1 X2_sky130_fd_sc_hd__fill_1
XFILLER_99_473 vssd1 vccd1 vssd1 vccd1 X2_sky130_ef_sc_hd__decap_40_12
XFILLER_59_337 vssd1 vccd1 vccd1 vssd1 X2_sky130_fd_sc_hd__fill_4
XFILLER_59_326 vssd1 vccd1 vccd1 vssd1 X2_sky130_fd_sc_hd__fill_8
XFILLER_101_434 vssd1 vccd1 vssd1 vccd1 X2_sky130_ef_sc_hd__decap_40_12
XFILLER_101_489 vssd1 vccd1 vssd1 vccd1 X2_sky130_ef_sc_hd__decap_40_12
XFILLER_86_189 vssd1 vccd1 vccd1 vssd1 X2_sky130_fd_sc_hd__fill_4
XFILLER_74_307 vccd1 vssd1 vccd1 vssd1 X2_sky130_fd_sc_hd__fill_1
XFILLER_27_223 vccd1 vssd1 vccd1 vssd1 X2_sky130_fd_sc_hd__fill_1
XFILLER_63_15 vssd1 vccd1 vssd1 vccd1 X2_sky130_ef_sc_hd__decap_40_12
XFILLER_15_429 vssd1 vccd1 vssd1 vccd1 X2_sky130_ef_sc_hd__decap_40_12
XFILLER_70_513 vssd1 vccd1 vssd1 vccd1 X2_sky130_ef_sc_hd__decap_40_12
XFILLER_70_557 vssd1 vccd1 vssd1 vccd1 X2_sky130_ef_sc_hd__decap_40_12
XFILLER_11_613 vssd1 vccd1 vccd1 vssd1 X2_sky130_fd_sc_hd__fill_2
XFILLER_23_473 vssd1 vccd1 vssd1 vccd1 X2_sky130_ef_sc_hd__decap_40_12
XTAP_TAPCELL_ROW_53_799 vccd1 vssd1 X2_sky130_fd_sc_hd__tapvpwrvgnd_1
XFILLER_7_617 vssd1 vccd1 vccd1 vssd1 X2_sky130_fd_sc_hd__fill_8
XANTENNA__326__A2 _291_/B vssd1 vccd1 vccd1 vssd1 X2_sky130_fd_sc_hd__diode_2
XFILLER_10_189 vssd1 vccd1 vccd1 vssd1 X2_sky130_fd_sc_hd__fill_4
XFILLER_12_41 vssd1 vccd1 vssd1 vccd1 X2_sky130_ef_sc_hd__decap_40_12
XFILLER_12_85 vssd1 vccd1 vssd1 vccd1 X2_sky130_ef_sc_hd__decap_40_12
XFILLER_2_333 vssd1 vccd1 vssd1 vccd1 X2_sky130_ef_sc_hd__decap_40_12
XFILLER_2_377 vssd1 vccd1 vssd1 vccd1 X2_sky130_ef_sc_hd__decap_40_12
Xtop_soc_69 wbs_dat_o[17] top_soc_69/HI vccd1 vssd1 vssd1 vccd1 X2_sky130_fd_sc_hd__conb_1
XFILLER_78_613 vssd1 vccd1 vssd1 vccd1 X2_sky130_ef_sc_hd__decap_40_12
XFILLER_77_167 vccd1 vssd1 vccd1 vssd1 X2_sky130_fd_sc_hd__fill_1
XFILLER_65_329 vssd1 vccd1 vccd1 vssd1 X2_sky130_fd_sc_hd__fill_4
XFILLER_92_137 vssd1 vccd1 vccd1 vssd1 X2_sky130_fd_sc_hd__fill_2
XPHY_EDGE_ROW_16_Right_16 vccd1 vssd1 vccd1 vssd1 X2_sky130_fd_sc_hd__decap_3
XFILLER_18_245 vssd1 vccd1 vccd1 vssd1 X2_sky130_fd_sc_hd__fill_4
XFILLER_37_93 vssd1 vccd1 vssd1 vccd1 X2_sky130_ef_sc_hd__decap_40_12
XFILLER_18_289 vssd1 vccd1 vssd1 vccd1 X2_sky130_ef_sc_hd__decap_40_12
XFILLER_73_373 vssd1 vccd1 vssd1 vccd1 X2_sky130_ef_sc_hd__decap_40_12
XTAP_TAPCELL_ROW_44_700 vccd1 vssd1 X2_sky130_fd_sc_hd__tapvpwrvgnd_1
XFILLER_61_557 vssd1 vccd1 vccd1 vssd1 X2_sky130_fd_sc_hd__fill_2
XFILLER_14_473 vssd1 vccd1 vccd1 vssd1 X2_sky130_fd_sc_hd__fill_2
X_417_ vccd1 vssd1 vccd1 vssd1 _406_/B _406_/A _416_/B _417_/X X2_sky130_fd_sc_hd__a21o_1
XFILLER_53_81 vssd1 vccd1 vssd1 vccd1 X2_sky130_ef_sc_hd__decap_40_12
XFILLER_41_281 vssd1 vccd1 vccd1 vssd1 X2_sky130_fd_sc_hd__fill_8
XTAP_TAPCELL_ROW_99_1304 vccd1 vssd1 X2_sky130_fd_sc_hd__tapvpwrvgnd_1
X_348_ vssd1 vccd1 _422_/A _556_/D _348_/B vccd1 vssd1 X2_sky130_fd_sc_hd__xnor2_2
XPHY_EDGE_ROW_25_Right_25 vccd1 vssd1 vccd1 vssd1 X2_sky130_fd_sc_hd__decap_3
X_279_ vssd1 vccd1 vccd1 vssd1 _600_/D hold73/X _289_/S _279_/A0 X2_sky130_fd_sc_hd__mux2_1
XFILLER_5_193 vssd1 vccd1 vssd1 vccd1 X2_sky130_ef_sc_hd__decap_40_12
XFILLER_45_3 vssd1 vccd1 vssd1 vccd1 X2_sky130_ef_sc_hd__decap_40_12
XFILLER_96_421 vssd1 vccd1 vssd1 vccd1 X2_sky130_ef_sc_hd__decap_40_12
XFILLER_69_624 vccd1 vssd1 vccd1 vssd1 X2_sky130_fd_sc_hd__fill_1
XFILLER_68_189 vssd1 vccd1 vccd1 vssd1 X2_sky130_fd_sc_hd__fill_4
XPHY_EDGE_ROW_34_Right_34 vccd1 vssd1 vccd1 vssd1 X2_sky130_fd_sc_hd__decap_3
XFILLER_83_137 vssd1 vccd1 vssd1 vccd1 X2_sky130_ef_sc_hd__decap_40_12
XFILLER_64_351 vssd1 vccd1 vssd1 vccd1 X2_sky130_ef_sc_hd__decap_40_12
XFILLER_52_502 vssd1 vccd1 vssd1 vccd1 X2_sky130_ef_sc_hd__decap_40_12
XFILLER_91_181 vssd1 vccd1 vssd1 vccd1 X2_sky130_ef_sc_hd__decap_40_12
XFILLER_20_421 vssd1 vccd1 vssd1 vccd1 X2_sky130_ef_sc_hd__decap_40_12
XANTENNA__308__A2 _303_/X vssd1 vccd1 vccd1 vssd1 X2_sky130_fd_sc_hd__diode_2
XTAP_TAPCELL_ROW_50_769 vccd1 vssd1 X2_sky130_fd_sc_hd__tapvpwrvgnd_1
XPHY_EDGE_ROW_43_Right_43 vccd1 vssd1 vccd1 vssd1 X2_sky130_fd_sc_hd__decap_3
XTAP_TAPCELL_ROW_72_1009 vccd1 vssd1 X2_sky130_fd_sc_hd__tapvpwrvgnd_1
XFILLER_99_281 vssd1 vccd1 vccd1 vssd1 X2_sky130_fd_sc_hd__fill_2
XFILLER_58_15 vssd1 vccd1 vssd1 vccd1 X2_sky130_ef_sc_hd__decap_40_12
XFILLER_101_253 vssd1 vccd1 vccd1 vssd1 X2_sky130_fd_sc_hd__fill_2
XFILLER_59_167 vccd1 vssd1 vccd1 vssd1 X2_sky130_fd_sc_hd__fill_1
XPHY_EDGE_ROW_52_Right_52 vccd1 vssd1 vccd1 vssd1 X2_sky130_fd_sc_hd__decap_3
XFILLER_74_137 vssd1 vccd1 vccd1 vssd1 X2_sky130_fd_sc_hd__fill_2
XTAP_TAPCELL_ROW_58_858 vccd1 vssd1 X2_sky130_fd_sc_hd__tapvpwrvgnd_1
XFILLER_28_587 vccd1 vssd1 vccd1 vssd1 X2_sky130_fd_sc_hd__fill_1
XFILLER_70_321 vssd1 vccd1 vssd1 vccd1 X2_sky130_ef_sc_hd__decap_40_12
XFILLER_55_373 vssd1 vccd1 vssd1 vccd1 X2_sky130_ef_sc_hd__decap_40_12
XFILLER_15_237 vssd1 vccd1 vssd1 vccd1 X2_sky130_ef_sc_hd__decap_40_12
XTAP_TAPCELL_ROW_83_1138 vccd1 vssd1 X2_sky130_fd_sc_hd__tapvpwrvgnd_1
XFILLER_70_365 vssd1 vccd1 vssd1 vccd1 X2_sky130_ef_sc_hd__decap_40_12
XFILLER_23_281 vssd1 vccd1 vssd1 vccd1 X2_sky130_ef_sc_hd__decap_40_12
XPHY_EDGE_ROW_61_Right_61 vccd1 vssd1 vccd1 vssd1 X2_sky130_fd_sc_hd__decap_3
XFILLER_23_51 vssd1 vccd1 vccd1 vssd1 X2_sky130_fd_sc_hd__fill_4
XFILLER_7_447 vccd1 vssd1 vccd1 vssd1 X2_sky130_fd_sc_hd__fill_1
XFILLER_99_55 vccd1 vssd1 vccd1 vssd1 X2_sky130_fd_sc_hd__fill_1
XTAP_TAPCELL_ROW_94_1256 vccd1 vssd1 X2_sky130_fd_sc_hd__tapvpwrvgnd_1
XFILLER_2_141 vssd1 vccd1 vssd1 vccd1 X2_sky130_ef_sc_hd__decap_40_12
XFILLER_78_421 vssd1 vccd1 vssd1 vccd1 X2_sky130_ef_sc_hd__decap_40_12
XPHY_EDGE_ROW_70_Right_70 vccd1 vssd1 vccd1 vssd1 X2_sky130_fd_sc_hd__decap_3
XFILLER_38_318 vssd1 vccd1 vccd1 vssd1 X2_sky130_fd_sc_hd__fill_2
XFILLER_65_137 vssd1 vccd1 vssd1 vccd1 X2_sky130_ef_sc_hd__decap_40_12
XFILLER_48_81 vssd1 vccd1 vccd1 vssd1 X2_sky130_fd_sc_hd__fill_2
XFILLER_0_55 vccd1 vssd1 vccd1 vssd1 X2_sky130_fd_sc_hd__fill_1
XFILLER_46_362 vssd1 vccd1 vccd1 vssd1 X2_sky130_fd_sc_hd__fill_2
XFILLER_34_568 vssd1 vccd1 vssd1 vccd1 X2_sky130_ef_sc_hd__decap_40_12
XFILLER_73_181 vssd1 vccd1 vssd1 vccd1 X2_sky130_ef_sc_hd__decap_40_12
XFILLER_61_332 vssd1 vccd1 vccd1 vssd1 X2_sky130_fd_sc_hd__fill_4
XFILLER_61_376 vssd1 vccd1 vssd1 vccd1 X2_sky130_ef_sc_hd__decap_40_12
XANTENNA_clkbuf_0_wb_clk_i_A wb_clk_i vssd1 vccd1 vccd1 vssd1 X2_sky130_fd_sc_hd__diode_2
XFILLER_28_29 vssd1 vccd1 vssd1 vccd1 X2_sky130_ef_sc_hd__decap_40_12
XFILLER_96_251 vccd1 vssd1 vccd1 vssd1 X2_sky130_fd_sc_hd__fill_1
XFILLER_84_413 vssd1 vccd1 vccd1 vssd1 X2_sky130_fd_sc_hd__fill_4
XFILLER_56_137 vssd1 vccd1 vccd1 vssd1 X2_sky130_fd_sc_hd__fill_2
XFILLER_84_457 vssd1 vccd1 vssd1 vccd1 X2_sky130_ef_sc_hd__decap_40_12
XTAP_TAPCELL_ROW_27_519 vccd1 vssd1 X2_sky130_fd_sc_hd__tapvpwrvgnd_1
XFILLER_37_362 vssd1 vccd1 vccd1 vssd1 X2_sky130_fd_sc_hd__fill_2
XTAP_TAPCELL_ROW_55_828 vccd1 vssd1 X2_sky130_fd_sc_hd__tapvpwrvgnd_1
XFILLER_25_557 vssd1 vccd1 vccd1 vssd1 X2_sky130_fd_sc_hd__fill_2
XFILLER_37_395 vccd1 vssd1 vccd1 vssd1 X2_sky130_fd_sc_hd__fill_1
XFILLER_52_365 vssd1 vccd1 vccd1 vssd1 X2_sky130_fd_sc_hd__fill_4
XFILLER_20_251 vccd1 vssd1 vccd1 vssd1 X2_sky130_fd_sc_hd__fill_1
XFILLER_60_27 vccd1 vssd1 vccd1 vssd1 X2_sky130_fd_sc_hd__fill_1
XFILLER_4_417 vssd1 vccd1 vccd1 vssd1 X2_sky130_fd_sc_hd__fill_2
XFILLER_0_601 vssd1 vccd1 vssd1 vccd1 X2_sky130_ef_sc_hd__decap_40_12
XFILLER_69_69 vssd1 vccd1 vssd1 vccd1 X2_sky130_ef_sc_hd__decap_40_12
XTAP_TAPCELL_ROW_7_299 vccd1 vssd1 X2_sky130_fd_sc_hd__tapvpwrvgnd_1
XFILLER_87_273 vssd1 vccd1 vccd1 vssd1 X2_sky130_fd_sc_hd__fill_4
XFILLER_85_57 vssd1 vccd1 vssd1 vccd1 X2_sky130_ef_sc_hd__decap_40_12
XFILLER_47_137 vssd1 vccd1 vssd1 vccd1 X2_sky130_ef_sc_hd__decap_40_12
XFILLER_63_608 vssd1 vccd1 vccd1 vssd1 X2_sky130_fd_sc_hd__fill_2
XFILLER_16_513 vssd1 vccd1 vssd1 vccd1 X2_sky130_ef_sc_hd__decap_40_12
XFILLER_16_557 vssd1 vccd1 vssd1 vccd1 X2_sky130_ef_sc_hd__decap_40_12
XFILLER_55_181 vssd1 vccd1 vssd1 vccd1 X2_sky130_ef_sc_hd__decap_40_12
XFILLER_31_505 vssd1 vccd1 vssd1 vccd1 X2_sky130_ef_sc_hd__decap_40_12
XFILLER_43_376 vssd1 vccd1 vccd1 vssd1 X2_sky130_fd_sc_hd__fill_2
XFILLER_70_195 vccd1 vssd1 vccd1 vssd1 X2_sky130_fd_sc_hd__fill_1
XFILLER_34_83 vccd1 vssd1 vccd1 vssd1 X2_sky130_fd_sc_hd__fill_1
XFILLER_11_273 vssd1 vccd1 vccd1 vssd1 X2_sky130_fd_sc_hd__fill_4
XFILLER_7_277 vssd1 vccd1 vccd1 vssd1 X2_sky130_fd_sc_hd__fill_2
XFILLER_3_461 vssd1 vccd1 vssd1 vccd1 X2_sky130_ef_sc_hd__decap_40_12
XFILLER_39_605 vccd1 vssd1 vccd1 vssd1 X2_sky130_fd_sc_hd__fill_1
XFILLER_78_251 vccd1 vssd1 vccd1 vssd1 X2_sky130_fd_sc_hd__fill_1
XFILLER_38_137 vssd1 vccd1 vccd1 vssd1 X2_sky130_fd_sc_hd__fill_2
XFILLER_93_221 vssd1 vccd1 vccd1 vssd1 X2_sky130_fd_sc_hd__fill_2
XFILLER_66_413 vssd1 vccd1 vccd1 vssd1 X2_sky130_fd_sc_hd__fill_4
XFILLER_81_405 vssd1 vccd1 vssd1 vccd1 X2_sky130_ef_sc_hd__decap_40_12
XFILLER_66_457 vssd1 vccd1 vssd1 vccd1 X2_sky130_ef_sc_hd__decap_40_12
XFILLER_54_619 vssd1 vccd1 vccd1 vssd1 X2_sky130_fd_sc_hd__fill_2
XFILLER_19_373 vssd1 vccd1 vssd1 vccd1 X2_sky130_ef_sc_hd__decap_40_12
XFILLER_81_449 vssd1 vccd1 vssd1 vccd1 X2_sky130_ef_sc_hd__decap_40_12
XFILLER_46_181 vssd1 vccd1 vccd1 vssd1 X2_sky130_fd_sc_hd__fill_2
XFILLER_34_365 vccd1 vssd1 vccd1 vssd1 X2_sky130_fd_sc_hd__fill_1
XFILLER_34_387 vssd1 vccd1 vccd1 vssd1 X2_sky130_fd_sc_hd__fill_2
XFILLER_34_398 vssd1 vccd1 vccd1 vssd1 X2_sky130_fd_sc_hd__fill_2
XTAP_TAPCELL_ROW_60_875 vccd1 vssd1 X2_sky130_fd_sc_hd__tapvpwrvgnd_1
XTAP_TAPCELL_ROW_32_577 vccd1 vssd1 X2_sky130_fd_sc_hd__tapvpwrvgnd_1
XFILLER_89_505 vssd1 vccd1 vssd1 vccd1 X2_sky130_ef_sc_hd__decap_40_12
XFILLER_84_221 vssd1 vccd1 vssd1 vccd1 X2_sky130_ef_sc_hd__decap_40_12
XFILLER_69_273 vssd1 vccd1 vccd1 vssd1 X2_sky130_fd_sc_hd__fill_4
XPHY_EDGE_ROW_2_Right_2 vccd1 vssd1 vccd1 vssd1 X2_sky130_fd_sc_hd__decap_3
XTAP_TAPCELL_ROW_4_269 vccd1 vssd1 X2_sky130_fd_sc_hd__tapvpwrvgnd_1
XFILLER_29_137 vssd1 vccd1 vssd1 vccd1 X2_sky130_ef_sc_hd__decap_40_12
XTAP_TAPCELL_ROW_68_964 vccd1 vssd1 X2_sky130_fd_sc_hd__tapvpwrvgnd_1
XFILLER_45_619 vccd1 vssd1 vccd1 vssd1 X2_sky130_fd_sc_hd__fill_1
XFILLER_84_265 vssd1 vccd1 vccd1 vssd1 X2_sky130_fd_sc_hd__fill_2
XFILLER_55_27 vssd1 vccd1 vssd1 vccd1 X2_sky130_ef_sc_hd__decap_40_12
XFILLER_37_181 vssd1 vccd1 vccd1 vssd1 X2_sky130_fd_sc_hd__fill_2
XFILLER_65_490 vssd1 vccd1 vssd1 vccd1 X2_sky130_ef_sc_hd__decap_40_12
XFILLER_13_505 vssd1 vccd1 vssd1 vccd1 X2_sky130_ef_sc_hd__decap_40_12
XFILLER_71_15 vssd1 vccd1 vssd1 vccd1 X2_sky130_ef_sc_hd__decap_40_12
XFILLER_52_195 vccd1 vssd1 vccd1 vssd1 X2_sky130_fd_sc_hd__fill_1
XFILLER_40_368 vssd1 vccd1 vccd1 vssd1 X2_sky130_fd_sc_hd__fill_4
XFILLER_20_41 vssd1 vccd1 vssd1 vccd1 X2_sky130_ef_sc_hd__decap_40_12
XFILLER_20_85 vssd1 vccd1 vssd1 vccd1 X2_sky130_ef_sc_hd__decap_40_12
XTAP_TAPCELL_ROW_91_1226 vccd1 vssd1 X2_sky130_fd_sc_hd__tapvpwrvgnd_1
XFILLER_48_402 vssd1 vccd1 vccd1 vssd1 X2_sky130_fd_sc_hd__fill_2
XANTENNA_input32_A wbs_dat_i[3] vssd1 vccd1 vccd1 vssd1 X2_sky130_fd_sc_hd__diode_2
XFILLER_0_475 vccd1 vssd1 vccd1 vssd1 X2_sky130_fd_sc_hd__fill_1
XFILLER_75_221 vssd1 vccd1 vccd1 vssd1 X2_sky130_fd_sc_hd__fill_2
Xhold50 _583_/D _443_/X vccd1 vssd1 vssd1 vccd1 X2_sky130_fd_sc_hd__dlygate4sd3_1
Xhold61 hold61/X _563_/Q vccd1 vssd1 vssd1 vccd1 X2_sky130_fd_sc_hd__dlygate4sd3_1
Xhold72 hold72/X _596_/Q vccd1 vssd1 vssd1 vccd1 X2_sky130_fd_sc_hd__dlygate4sd3_1
Xhold83 _542_/D _437_/Y vccd1 vssd1 vssd1 vccd1 X2_sky130_fd_sc_hd__dlygate4sd3_1
XPHY_EDGE_ROW_11_Left_113 vccd1 vssd1 vccd1 vssd1 X2_sky130_fd_sc_hd__decap_3
XFILLER_63_405 vssd1 vccd1 vssd1 vccd1 X2_sky130_ef_sc_hd__decap_40_12
XFILLER_16_321 vssd1 vccd1 vssd1 vccd1 X2_sky130_ef_sc_hd__decap_40_12
XTAP_TAPCELL_ROW_89_1199 vccd1 vssd1 X2_sky130_fd_sc_hd__tapvpwrvgnd_1
XFILLER_63_449 vssd1 vccd1 vssd1 vccd1 X2_sky130_ef_sc_hd__decap_40_12
XFILLER_16_365 vssd1 vccd1 vssd1 vccd1 X2_sky130_ef_sc_hd__decap_40_12
X_596_ vccd1 vssd1 vccd1 vssd1 _596_/Q _516_/Y _596_/D _609_/CLK X2_sky130_fd_sc_hd__dfstp_1
XFILLER_31_335 vccd1 vssd1 vccd1 vssd1 X2_sky130_fd_sc_hd__fill_1
XFILLER_45_93 vssd1 vccd1 vssd1 vccd1 X2_sky130_ef_sc_hd__decap_40_12
XTAP_TAPCELL_ROW_100_1322 vccd1 vssd1 X2_sky130_fd_sc_hd__tapvpwrvgnd_1
XFILLER_8_531 vccd1 vssd1 vccd1 vssd1 X2_sky130_fd_sc_hd__fill_1
XFILLER_61_81 vssd1 vccd1 vssd1 vccd1 X2_sky130_ef_sc_hd__decap_40_12
XPHY_EDGE_ROW_20_Left_122 vccd1 vssd1 vccd1 vssd1 X2_sky130_fd_sc_hd__decap_3
XFILLER_6_65 vssd1 vccd1 vssd1 vccd1 X2_sky130_ef_sc_hd__decap_40_12
XFILLER_98_357 vssd1 vccd1 vccd1 vssd1 X2_sky130_fd_sc_hd__fill_4
XFILLER_100_318 vssd1 vccd1 vssd1 vccd1 X2_sky130_ef_sc_hd__decap_40_12
XFILLER_66_221 vssd1 vccd1 vssd1 vccd1 X2_sky130_ef_sc_hd__decap_40_12
XTAP_TAPCELL_ROW_1_228 vccd1 vssd1 X2_sky130_fd_sc_hd__tapvpwrvgnd_1
XFILLER_94_585 vssd1 vccd1 vccd1 vssd1 X2_sky130_fd_sc_hd__fill_2
XFILLER_66_265 vssd1 vccd1 vssd1 vccd1 X2_sky130_ef_sc_hd__decap_40_12
XFILLER_19_181 vssd1 vccd1 vssd1 vccd1 X2_sky130_ef_sc_hd__decap_40_12
XTAP_TAPCELL_ROW_37_625 vccd1 vssd1 X2_sky130_fd_sc_hd__tapvpwrvgnd_1
XTAP_TAPCELL_ROW_65_934 vccd1 vssd1 X2_sky130_fd_sc_hd__tapvpwrvgnd_1
XFILLER_81_279 vccd1 vssd1 vccd1 vssd1 X2_sky130_fd_sc_hd__fill_1
XFILLER_50_611 vccd1 vssd1 vccd1 vssd1 X2_sky130_fd_sc_hd__fill_1
XFILLER_22_357 vssd1 vccd1 vccd1 vssd1 X2_sky130_fd_sc_hd__fill_4
XFILLER_34_195 vccd1 vssd1 vccd1 vssd1 X2_sky130_fd_sc_hd__fill_1
XTAP_TAPCELL_ROW_9_317 vccd1 vssd1 X2_sky130_fd_sc_hd__tapvpwrvgnd_1
XTAP_TAPCELL_ROW_77_1070 vccd1 vssd1 X2_sky130_fd_sc_hd__tapvpwrvgnd_1
XFILLER_1_217 vssd1 vccd1 vccd1 vssd1 X2_sky130_fd_sc_hd__fill_4
XFILLER_89_335 vccd1 vssd1 vccd1 vssd1 X2_sky130_fd_sc_hd__fill_1
XFILLER_66_26 vssd1 vccd1 vccd1 vssd1 X2_sky130_fd_sc_hd__fill_2
XFILLER_85_541 vssd1 vccd1 vssd1 vccd1 X2_sky130_ef_sc_hd__decap_40_12
XFILLER_57_221 vssd1 vccd1 vccd1 vssd1 X2_sky130_fd_sc_hd__fill_2
XFILLER_85_585 vssd1 vccd1 vssd1 vccd1 X2_sky130_ef_sc_hd__decap_40_12
XFILLER_45_405 vssd1 vccd1 vssd1 vccd1 X2_sky130_ef_sc_hd__decap_40_12
XFILLER_57_298 vssd1 vccd1 vssd1 vccd1 X2_sky130_ef_sc_hd__decap_40_12
XFILLER_45_449 vssd1 vccd1 vssd1 vccd1 X2_sky130_ef_sc_hd__decap_40_12
XFILLER_45_438 vssd1 vccd1 vccd1 vssd1 X2_sky130_fd_sc_hd__fill_2
X_450_ vccd1 vssd1 vccd1 vssd1 hold52/X _589_/D _450_/A1 _440_/Y X2_sky130_fd_sc_hd__a21boi_1
XFILLER_60_419 vccd1 vssd1 vccd1 vssd1 X2_sky130_fd_sc_hd__fill_1
XFILLER_41_600 vssd1 vccd1 vssd1 vccd1 X2_sky130_ef_sc_hd__decap_40_12
X_381_ vssd1 vccd1 vssd1 vccd1 _381_/X _378_/X _411_/A _380_/X X2_sky130_fd_sc_hd__a21bo_1
XFILLER_13_335 vccd1 vssd1 vccd1 vssd1 X2_sky130_fd_sc_hd__fill_1
XFILLER_40_121 vssd1 vccd1 vssd1 vccd1 X2_sky130_ef_sc_hd__decap_40_12
XFILLER_9_317 vssd1 vccd1 vssd1 vccd1 X2_sky130_ef_sc_hd__decap_40_12
XFILLER_40_165 vssd1 vccd1 vssd1 vccd1 X2_sky130_ef_sc_hd__decap_40_12
XFILLER_5_501 vssd1 vccd1 vccd1 vssd1 X2_sky130_fd_sc_hd__fill_2
XFILLER_31_51 vssd1 vccd1 vccd1 vssd1 X2_sky130_fd_sc_hd__fill_4
Xoutput51 vccd1 vssd1 wbs_dat_o[2] _559_/Q vccd1 vssd1 X2_sky130_fd_sc_hd__buf_2
XFILLER_0_272 vssd1 vccd1 vccd1 vssd1 X2_sky130_fd_sc_hd__fill_4
XANTENNA_input35_X _449_/A1 vssd1 vccd1 vccd1 vssd1 X2_sky130_fd_sc_hd__diode_2
XFILLER_0_294 vssd1 vccd1 vccd1 vssd1 X2_sky130_fd_sc_hd__fill_2
XFILLER_48_221 vssd1 vccd1 vssd1 vccd1 X2_sky130_ef_sc_hd__decap_40_12
XFILLER_76_585 vssd1 vccd1 vccd1 vssd1 X2_sky130_fd_sc_hd__fill_2
XFILLER_48_265 vssd1 vccd1 vssd1 vccd1 X2_sky130_ef_sc_hd__decap_40_12
XFILLER_56_81 vssd1 vccd1 vccd1 vssd1 X2_sky130_fd_sc_hd__fill_2
XFILLER_48_298 vssd1 vccd1 vccd1 vssd1 X2_sky130_fd_sc_hd__fill_8
XFILLER_63_279 vccd1 vssd1 vccd1 vssd1 X2_sky130_fd_sc_hd__fill_1
XTAP_TAPCELL_ROW_62_904 vccd1 vssd1 X2_sky130_fd_sc_hd__tapvpwrvgnd_1
XFILLER_51_419 vssd1 vccd1 vssd1 vccd1 X2_sky130_ef_sc_hd__decap_40_12
XFILLER_16_195 vccd1 vssd1 vccd1 vssd1 X2_sky130_fd_sc_hd__fill_1
X_579_ vccd1 vssd1 vccd1 vssd1 _579_/Q _499_/Y _579_/D _609_/CLK X2_sky130_fd_sc_hd__dfstp_1
XFILLER_31_165 vssd1 vccd1 vccd1 vssd1 X2_sky130_fd_sc_hd__fill_2
XTAP_TAPCELL_ROW_14_374 vccd1 vssd1 X2_sky130_fd_sc_hd__tapvpwrvgnd_1
XFILLER_75_3 vssd1 vccd1 vssd1 vccd1 X2_sky130_ef_sc_hd__decap_40_12
XTAP_TAPCELL_ROW_70_992 vccd1 vssd1 X2_sky130_fd_sc_hd__tapvpwrvgnd_1
XTAP_TAPCELL_ROW_42_683 vccd1 vssd1 X2_sky130_fd_sc_hd__tapvpwrvgnd_1
XFILLER_8_361 vssd1 vccd1 vccd1 vssd1 X2_sky130_fd_sc_hd__fill_2
XFILLER_98_121 vssd1 vccd1 vssd1 vccd1 X2_sky130_ef_sc_hd__decap_40_12
XPHY_EDGE_ROW_99_Right_99 vccd1 vssd1 vccd1 vssd1 X2_sky130_fd_sc_hd__decap_3
XFILLER_98_165 vssd1 vccd1 vssd1 vccd1 X2_sky130_ef_sc_hd__decap_40_12
XFILLER_86_305 vssd1 vccd1 vccd1 vssd1 X2_sky130_fd_sc_hd__fill_2
XFILLER_39_221 vssd1 vccd1 vccd1 vssd1 X2_sky130_fd_sc_hd__fill_2
XFILLER_100_137 vssd1 vccd1 vccd1 vssd1 X2_sky130_fd_sc_hd__fill_2
XFILLER_67_541 vssd1 vccd1 vssd1 vccd1 X2_sky130_ef_sc_hd__decap_40_12
XFILLER_27_405 vssd1 vccd1 vssd1 vccd1 X2_sky130_ef_sc_hd__decap_40_12
XFILLER_39_265 vssd1 vccd1 vccd1 vssd1 X2_sky130_fd_sc_hd__fill_2
XFILLER_67_585 vssd1 vccd1 vccd1 vssd1 X2_sky130_fd_sc_hd__fill_4
XFILLER_27_449 vssd1 vccd1 vssd1 vccd1 X2_sky130_ef_sc_hd__decap_40_12
XFILLER_36_29 vssd1 vccd1 vssd1 vccd1 X2_sky130_ef_sc_hd__decap_40_12
XFILLER_82_533 vssd1 vccd1 vssd1 vccd1 X2_sky130_ef_sc_hd__decap_40_12
XFILLER_22_121 vssd1 vccd1 vssd1 vccd1 X2_sky130_ef_sc_hd__decap_40_12
XFILLER_10_305 vssd1 vccd1 vccd1 vssd1 X2_sky130_fd_sc_hd__fill_2
XFILLER_22_165 vssd1 vccd1 vssd1 vccd1 X2_sky130_ef_sc_hd__decap_40_12
XFILLER_50_485 vccd1 vssd1 vccd1 vssd1 X2_sky130_fd_sc_hd__fill_1
XFILLER_6_309 vssd1 vccd1 vssd1 vccd1 X2_sky130_ef_sc_hd__decap_40_12
XFILLER_77_305 vssd1 vccd1 vssd1 vccd1 X2_sky130_ef_sc_hd__decap_40_12
XFILLER_89_165 vssd1 vccd1 vccd1 vssd1 X2_sky130_fd_sc_hd__fill_2
XFILLER_77_69 vssd1 vccd1 vssd1 vccd1 X2_sky130_ef_sc_hd__decap_40_12
XFILLER_77_349 vssd1 vccd1 vssd1 vccd1 X2_sky130_ef_sc_hd__decap_40_12
XFILLER_92_319 vccd1 vssd1 vccd1 vssd1 X2_sky130_fd_sc_hd__fill_1
XFILLER_93_57 vssd1 vccd1 vssd1 vccd1 X2_sky130_ef_sc_hd__decap_40_12
XFILLER_85_393 vssd1 vccd1 vssd1 vccd1 X2_sky130_ef_sc_hd__decap_40_12
XTAP_TAPCELL_ROW_86_1169 vccd1 vssd1 X2_sky130_fd_sc_hd__tapvpwrvgnd_1
X_502_ vccd1 vssd1 vccd1 vssd1 _502_/Y _527_/A X2_sky130_fd_sc_hd__inv_2
XFILLER_73_588 vssd1 vccd1 vccd1 vssd1 X2_sky130_fd_sc_hd__fill_2
X_433_ vccd1 vssd1 vssd1 vccd1 _433_/C _555_/D _554_/D _434_/B X2_sky130_fd_sc_hd__nor3_1
XFILLER_45_279 vccd1 vssd1 vccd1 vssd1 X2_sky130_fd_sc_hd__fill_1
XFILLER_60_249 vssd1 vccd1 vccd1 vssd1 X2_sky130_fd_sc_hd__fill_2
XFILLER_9_125 vssd1 vccd1 vssd1 vccd1 X2_sky130_ef_sc_hd__decap_40_12
XFILLER_13_165 vssd1 vccd1 vccd1 vssd1 X2_sky130_fd_sc_hd__fill_2
X_364_ vccd1 vssd1 vssd1 vccd1 _548_/Q hold4/A _368_/A X2_sky130_fd_sc_hd__nand2b_1
XFILLER_41_452 vssd1 vccd1 vssd1 vccd1 X2_sky130_ef_sc_hd__decap_40_12
X_295_ vssd1 vccd1 vccd1 vssd1 _578_/D hold68/X _299_/S _447_/A1 X2_sky130_fd_sc_hd__mux2_1
XFILLER_9_169 vssd1 vccd1 vssd1 vccd1 X2_sky130_ef_sc_hd__decap_40_12
XTAP_TAPCELL_ROW_11_344 vccd1 vssd1 X2_sky130_fd_sc_hd__tapvpwrvgnd_1
XFILLER_42_83 vccd1 vssd1 vccd1 vssd1 X2_sky130_fd_sc_hd__fill_1
XANTENNA__539__CLK _601_/CLK vssd1 vccd1 vccd1 vssd1 X2_sky130_fd_sc_hd__diode_2
XTAP_TAPCELL_ROW_97_1287 vccd1 vssd1 X2_sky130_fd_sc_hd__tapvpwrvgnd_1
XFILLER_47_7 vssd1 vccd1 vccd1 vssd1 X2_sky130_fd_sc_hd__fill_2
XFILLER_3_55 vccd1 vssd1 vccd1 vssd1 X2_sky130_fd_sc_hd__fill_1
XFILLER_95_113 vssd1 vccd1 vssd1 vccd1 X2_sky130_ef_sc_hd__decap_40_12
XFILLER_68_327 vssd1 vccd1 vccd1 vssd1 X2_sky130_fd_sc_hd__fill_2
XFILLER_68_305 vssd1 vccd1 vccd1 vssd1 X2_sky130_fd_sc_hd__fill_2
XFILLER_49_585 vccd1 vssd1 vccd1 vssd1 X2_sky130_fd_sc_hd__fill_1
XFILLER_64_533 vssd1 vccd1 vssd1 vccd1 X2_sky130_ef_sc_hd__decap_40_12
XTAP_TAPCELL_ROW_19_433 vccd1 vssd1 X2_sky130_fd_sc_hd__tapvpwrvgnd_1
XFILLER_91_352 vssd1 vccd1 vssd1 vccd1 X2_sky130_ef_sc_hd__decap_40_12
XTAP_TAPCELL_ROW_47_742 vccd1 vssd1 X2_sky130_fd_sc_hd__tapvpwrvgnd_1
XFILLER_24_419 vccd1 vssd1 vccd1 vssd1 X2_sky130_fd_sc_hd__fill_1
XFILLER_32_452 vssd1 vccd1 vssd1 vccd1 X2_sky130_ef_sc_hd__decap_40_12
XFILLER_99_430 vssd1 vccd1 vccd1 vssd1 X2_sky130_fd_sc_hd__fill_2
XFILLER_99_485 vssd1 vccd1 vssd1 vccd1 X2_sky130_ef_sc_hd__decap_40_12
XFILLER_59_305 vssd1 vccd1 vccd1 vssd1 X2_sky130_fd_sc_hd__fill_4
XFILLER_101_446 vssd1 vccd1 vccd1 vssd1 X2_sky130_fd_sc_hd__fill_2
XFILLER_59_349 vssd1 vccd1 vssd1 vccd1 X2_sky130_ef_sc_hd__decap_40_12
XFILLER_67_393 vssd1 vccd1 vssd1 vccd1 X2_sky130_ef_sc_hd__decap_40_12
XFILLER_82_363 vccd1 vssd1 vccd1 vssd1 X2_sky130_fd_sc_hd__fill_1
XFILLER_55_566 vssd1 vccd1 vssd1 vccd1 X2_sky130_ef_sc_hd__decap_40_12
XFILLER_27_279 vccd1 vssd1 vccd1 vssd1 X2_sky130_fd_sc_hd__fill_1
XFILLER_70_525 vssd1 vccd1 vccd1 vssd1 X2_sky130_fd_sc_hd__fill_4
XFILLER_63_27 vssd1 vccd1 vssd1 vccd1 X2_sky130_ef_sc_hd__decap_40_12
XFILLER_42_205 vssd1 vccd1 vssd1 vccd1 X2_sky130_ef_sc_hd__decap_40_12
XFILLER_23_441 vssd1 vccd1 vccd1 vssd1 X2_sky130_fd_sc_hd__fill_4
XFILLER_70_569 vssd1 vccd1 vssd1 vccd1 X2_sky130_ef_sc_hd__decap_40_12
XFILLER_23_485 vssd1 vccd1 vssd1 vccd1 X2_sky130_ef_sc_hd__decap_40_12
XFILLER_50_282 vssd1 vccd1 vssd1 vccd1 X2_sky130_ef_sc_hd__decap_40_12
XFILLER_6_139 vccd1 vssd1 vccd1 vssd1 X2_sky130_fd_sc_hd__fill_1
XFILLER_12_53 vssd1 vccd1 vssd1 vccd1 X2_sky130_ef_sc_hd__decap_40_12
XFILLER_12_97 vssd1 vccd1 vssd1 vccd1 X2_sky130_ef_sc_hd__decap_40_12
XFILLER_2_301 vssd1 vccd1 vccd1 vssd1 X2_sky130_fd_sc_hd__fill_4
XFILLER_2_345 vssd1 vccd1 vssd1 vccd1 X2_sky130_ef_sc_hd__decap_40_12
XFILLER_5_3 vssd1 vccd1 vssd1 vccd1 X2_sky130_ef_sc_hd__decap_40_12
XFILLER_2_389 vssd1 vccd1 vssd1 vccd1 X2_sky130_ef_sc_hd__decap_40_12
XFILLER_77_113 vssd1 vccd1 vssd1 vccd1 X2_sky130_ef_sc_hd__decap_40_12
XFILLER_93_617 vssd1 vccd1 vccd1 vssd1 X2_sky130_fd_sc_hd__fill_8
XFILLER_46_533 vssd1 vccd1 vccd1 vssd1 X2_sky130_fd_sc_hd__fill_8
XFILLER_61_503 vccd1 vssd1 vccd1 vssd1 X2_sky130_fd_sc_hd__fill_1
XFILLER_33_227 vccd1 vssd1 vccd1 vssd1 X2_sky130_fd_sc_hd__fill_1
XFILLER_73_385 vssd1 vccd1 vccd1 vssd1 X2_sky130_fd_sc_hd__fill_4
XTAP_TAPCELL_ROW_44_701 vccd1 vssd1 X2_sky130_fd_sc_hd__tapvpwrvgnd_1
XFILLER_61_569 vssd1 vccd1 vccd1 vssd1 X2_sky130_fd_sc_hd__fill_2
X_416_ vccd1 vssd1 vssd1 vccd1 _400_/A _416_/B _416_/Y X2_sky130_fd_sc_hd__nand2b_1
XTAP_TAPCELL_ROW_24_480 vccd1 vssd1 X2_sky130_fd_sc_hd__tapvpwrvgnd_1
XTAP_TAPCELL_ROW_99_1305 vccd1 vssd1 X2_sky130_fd_sc_hd__tapvpwrvgnd_1
XFILLER_53_93 vssd1 vccd1 vssd1 vccd1 X2_sky130_ef_sc_hd__decap_40_12
X_347_ vccd1 vssd1 vssd1 vccd1 _628_/A _347_/A _347_/B X2_sky130_fd_sc_hd__or2_1
X_278_ vssd1 vccd1 vccd1 vssd1 _601_/D hold25/X _289_/S _278_/A0 X2_sky130_fd_sc_hd__mux2_1
XFILLER_5_161 vssd1 vccd1 vccd1 vssd1 X2_sky130_fd_sc_hd__fill_4
XFILLER_38_3 vssd1 vccd1 vssd1 vccd1 X2_sky130_ef_sc_hd__decap_40_12
XFILLER_96_411 vssd1 vccd1 vccd1 vssd1 X2_sky130_fd_sc_hd__fill_8
XFILLER_96_433 vssd1 vccd1 vssd1 vccd1 X2_sky130_ef_sc_hd__decap_40_12
XPHY_EDGE_ROW_3_Left_105 vccd1 vssd1 vccd1 vssd1 X2_sky130_fd_sc_hd__decap_3
XFILLER_96_477 vssd1 vccd1 vssd1 vccd1 X2_sky130_ef_sc_hd__decap_40_12
XFILLER_83_105 vssd1 vccd1 vccd1 vssd1 X2_sky130_fd_sc_hd__fill_4
XFILLER_49_393 vccd1 vssd1 vccd1 vssd1 X2_sky130_fd_sc_hd__fill_1
XFILLER_83_149 vssd1 vccd1 vssd1 vccd1 X2_sky130_ef_sc_hd__decap_40_12
XFILLER_37_577 vccd1 vssd1 vccd1 vssd1 X2_sky130_fd_sc_hd__fill_1
XFILLER_64_363 vccd1 vssd1 vccd1 vssd1 X2_sky130_fd_sc_hd__fill_1
XFILLER_52_514 vssd1 vccd1 vssd1 vccd1 X2_sky130_ef_sc_hd__decap_40_12
XFILLER_24_249 vssd1 vccd1 vccd1 vssd1 X2_sky130_fd_sc_hd__fill_2
XFILLER_91_193 vssd1 vccd1 vssd1 vccd1 X2_sky130_ef_sc_hd__decap_40_12
XFILLER_52_558 vssd1 vccd1 vssd1 vccd1 X2_sky130_ef_sc_hd__decap_40_12
XFILLER_20_433 vssd1 vccd1 vssd1 vccd1 X2_sky130_ef_sc_hd__decap_40_12
XFILLER_20_477 vssd1 vccd1 vssd1 vccd1 X2_sky130_ef_sc_hd__decap_40_12
XFILLER_3_109 vssd1 vccd1 vccd1 vssd1 X2_sky130_fd_sc_hd__fill_2
XFILLER_58_27 vccd1 vssd1 vccd1 vssd1 X2_sky130_fd_sc_hd__fill_1
XFILLER_59_113 vssd1 vccd1 vssd1 vccd1 X2_sky130_ef_sc_hd__decap_40_12
XFILLER_75_617 vssd1 vccd1 vccd1 vssd1 X2_sky130_fd_sc_hd__fill_4
XFILLER_28_533 vssd1 vccd1 vssd1 vccd1 X2_sky130_ef_sc_hd__decap_40_12
XFILLER_101_276 vssd1 vccd1 vccd1 vssd1 X2_sky130_fd_sc_hd__fill_4
XFILLER_74_15 vssd1 vccd1 vssd1 vccd1 X2_sky130_ef_sc_hd__decap_40_12
XTAP_TAPCELL_ROW_58_859 vccd1 vssd1 X2_sky130_fd_sc_hd__tapvpwrvgnd_1
XFILLER_15_205 vssd1 vccd1 vssd1 vccd1 X2_sky130_ef_sc_hd__decap_40_12
XFILLER_55_385 vssd1 vccd1 vccd1 vssd1 X2_sky130_fd_sc_hd__fill_4
XFILLER_43_503 vccd1 vssd1 vccd1 vssd1 X2_sky130_fd_sc_hd__fill_1
XFILLER_15_249 vssd1 vccd1 vssd1 vccd1 X2_sky130_ef_sc_hd__decap_40_12
XTAP_TAPCELL_ROW_83_1128 vccd1 vssd1 X2_sky130_fd_sc_hd__tapvpwrvgnd_1
XFILLER_82_193 vssd1 vccd1 vccd1 vssd1 X2_sky130_fd_sc_hd__fill_2
XFILLER_70_333 vssd1 vccd1 vssd1 vccd1 X2_sky130_ef_sc_hd__decap_40_12
XFILLER_43_569 vssd1 vccd1 vccd1 vssd1 X2_sky130_fd_sc_hd__fill_2
XFILLER_70_377 vssd1 vccd1 vssd1 vccd1 X2_sky130_ef_sc_hd__decap_40_12
XPHY_EDGE_ROW_67_Left_169 vccd1 vssd1 vccd1 vssd1 X2_sky130_fd_sc_hd__decap_3
XFILLER_23_293 vssd1 vccd1 vssd1 vccd1 X2_sky130_ef_sc_hd__decap_40_12
XTAP_TAPCELL_ROW_21_450 vccd1 vssd1 X2_sky130_fd_sc_hd__tapvpwrvgnd_1
XTAP_TAPCELL_ROW_94_1257 vccd1 vssd1 X2_sky130_fd_sc_hd__tapvpwrvgnd_1
XFILLER_2_153 vssd1 vccd1 vssd1 vccd1 X2_sky130_ef_sc_hd__decap_40_12
XPHY_EDGE_ROW_76_Left_178 vccd1 vssd1 vccd1 vssd1 X2_sky130_fd_sc_hd__decap_3
XFILLER_2_197 vssd1 vccd1 vssd1 vccd1 X2_sky130_ef_sc_hd__decap_40_12
XFILLER_78_433 vssd1 vccd1 vssd1 vccd1 X2_sky130_ef_sc_hd__decap_40_12
XFILLER_78_477 vssd1 vccd1 vssd1 vccd1 X2_sky130_ef_sc_hd__decap_40_12
XFILLER_66_606 vccd1 vssd1 vccd1 vssd1 X2_sky130_fd_sc_hd__fill_1
XFILLER_65_105 vssd1 vccd1 vccd1 vssd1 X2_sky130_fd_sc_hd__fill_4
XFILLER_93_447 vccd1 vssd1 vccd1 vssd1 X2_sky130_fd_sc_hd__fill_1
XFILLER_81_609 vssd1 vccd1 vccd1 vssd1 X2_sky130_fd_sc_hd__fill_4
XFILLER_65_149 vssd1 vccd1 vssd1 vccd1 X2_sky130_ef_sc_hd__decap_40_12
XFILLER_46_330 vssd1 vccd1 vssd1 vccd1 X2_sky130_ef_sc_hd__decap_40_12
XFILLER_34_558 vssd1 vccd1 vccd1 vssd1 X2_sky130_fd_sc_hd__fill_2
XFILLER_73_193 vssd1 vccd1 vssd1 vccd1 X2_sky130_ef_sc_hd__decap_40_12
XFILLER_64_81 vssd1 vccd1 vccd1 vssd1 X2_sky130_fd_sc_hd__fill_2
XPHY_EDGE_ROW_85_Left_187 vccd1 vssd1 vccd1 vssd1 X2_sky130_fd_sc_hd__decap_3
XFILLER_61_388 vssd1 vccd1 vccd1 vssd1 X2_sky130_fd_sc_hd__fill_4
XPHY_EDGE_ROW_94_Left_196 vccd1 vssd1 vccd1 vssd1 X2_sky130_fd_sc_hd__decap_3
XFILLER_29_319 vssd1 vccd1 vssd1 vccd1 X2_sky130_ef_sc_hd__decap_40_12
XFILLER_57_617 vccd1 vssd1 vccd1 vssd1 X2_sky130_fd_sc_hd__fill_1
XFILLER_96_285 vssd1 vccd1 vccd1 vssd1 X2_sky130_fd_sc_hd__fill_2
XFILLER_84_469 vssd1 vccd1 vccd1 vssd1 X2_sky130_fd_sc_hd__fill_4
XFILLER_25_503 vccd1 vssd1 vccd1 vssd1 X2_sky130_fd_sc_hd__fill_1
XTAP_TAPCELL_ROW_55_829 vccd1 vssd1 X2_sky130_fd_sc_hd__tapvpwrvgnd_1
XFILLER_64_193 vssd1 vccd1 vccd1 vssd1 X2_sky130_fd_sc_hd__fill_2
XFILLER_44_29 vssd1 vccd1 vssd1 vccd1 X2_sky130_ef_sc_hd__decap_40_12
XFILLER_69_15 vssd1 vccd1 vssd1 vccd1 X2_sky130_ef_sc_hd__decap_40_12
XFILLER_0_613 vssd1 vccd1 vccd1 vssd1 X2_sky130_fd_sc_hd__fill_2
XFILLER_47_105 vssd1 vccd1 vccd1 vssd1 X2_sky130_fd_sc_hd__fill_4
XFILLER_18_41 vssd1 vccd1 vssd1 vccd1 X2_sky130_ef_sc_hd__decap_40_12
XFILLER_85_69 vssd1 vccd1 vssd1 vccd1 X2_sky130_ef_sc_hd__decap_40_12
XFILLER_75_447 vccd1 vssd1 vccd1 vssd1 X2_sky130_fd_sc_hd__fill_1
XFILLER_47_149 vssd1 vccd1 vssd1 vccd1 X2_sky130_ef_sc_hd__decap_40_12
XFILLER_16_525 vssd1 vccd1 vccd1 vssd1 X2_sky130_fd_sc_hd__fill_4
XFILLER_18_85 vssd1 vccd1 vssd1 vccd1 X2_sky130_ef_sc_hd__decap_40_12
XFILLER_28_363 vccd1 vssd1 vccd1 vssd1 X2_sky130_fd_sc_hd__fill_1
XFILLER_90_417 vssd1 vccd1 vccd1 vssd1 X2_sky130_fd_sc_hd__fill_2
XFILLER_55_193 vssd1 vccd1 vssd1 vccd1 X2_sky130_ef_sc_hd__decap_40_12
XFILLER_43_333 vssd1 vccd1 vccd1 vssd1 X2_sky130_fd_sc_hd__fill_2
XFILLER_16_569 vssd1 vccd1 vssd1 vccd1 X2_sky130_ef_sc_hd__decap_40_12
XFILLER_31_517 vssd1 vccd1 vssd1 vccd1 X2_sky130_ef_sc_hd__decap_40_12
XFILLER_70_141 vssd1 vccd1 vssd1 vccd1 X2_sky130_ef_sc_hd__decap_40_12
XFILLER_7_223 vccd1 vssd1 vccd1 vssd1 X2_sky130_fd_sc_hd__fill_1
XFILLER_50_83 vccd1 vssd1 vccd1 vssd1 X2_sky130_fd_sc_hd__fill_1
XFILLER_3_473 vssd1 vccd1 vssd1 vccd1 X2_sky130_ef_sc_hd__decap_40_12
XFILLER_39_617 vssd1 vccd1 vccd1 vssd1 X2_sky130_fd_sc_hd__fill_2
XFILLER_59_81 vssd1 vccd1 vssd1 vccd1 X2_sky130_ef_sc_hd__decap_40_12
XFILLER_66_469 vssd1 vccd1 vccd1 vssd1 X2_sky130_fd_sc_hd__fill_4
XFILLER_81_417 vssd1 vccd1 vssd1 vccd1 X2_sky130_ef_sc_hd__decap_40_12
XFILLER_19_385 vssd1 vccd1 vccd1 vssd1 X2_sky130_fd_sc_hd__fill_4
XFILLER_46_193 vssd1 vccd1 vccd1 vssd1 X2_sky130_fd_sc_hd__fill_2
XTAP_TAPCELL_ROW_32_567 vccd1 vssd1 X2_sky130_fd_sc_hd__tapvpwrvgnd_1
XTAP_TAPCELL_ROW_60_876 vccd1 vssd1 X2_sky130_fd_sc_hd__tapvpwrvgnd_1
XFILLER_89_517 vssd1 vccd1 vssd1 vccd1 X2_sky130_ef_sc_hd__decap_40_12
XANTENNA__302__Y _317_/B vssd1 vccd1 vccd1 vssd1 X2_sky130_fd_sc_hd__diode_2
XFILLER_97_561 vssd1 vccd1 vssd1 vccd1 X2_sky130_ef_sc_hd__decap_40_12
XFILLER_29_105 vssd1 vccd1 vccd1 vssd1 X2_sky130_fd_sc_hd__fill_4
XTAP_TAPCELL_ROW_4_259 vccd1 vssd1 X2_sky130_fd_sc_hd__tapvpwrvgnd_1
XFILLER_29_149 vssd1 vccd1 vssd1 vccd1 X2_sky130_ef_sc_hd__decap_40_12
XFILLER_84_233 vssd1 vccd1 vssd1 vccd1 X2_sky130_ef_sc_hd__decap_40_12
XTAP_TAPCELL_ROW_68_965 vccd1 vssd1 X2_sky130_fd_sc_hd__tapvpwrvgnd_1
XFILLER_57_447 vccd1 vssd1 vccd1 vssd1 X2_sky130_fd_sc_hd__fill_1
XFILLER_72_417 vssd1 vccd1 vccd1 vssd1 X2_sky130_fd_sc_hd__fill_2
XFILLER_55_39 vssd1 vccd1 vssd1 vccd1 X2_sky130_ef_sc_hd__decap_40_12
XFILLER_25_333 vssd1 vccd1 vccd1 vssd1 X2_sky130_fd_sc_hd__fill_2
XFILLER_13_517 vssd1 vccd1 vssd1 vccd1 X2_sky130_ef_sc_hd__decap_40_12
XFILLER_52_141 vssd1 vccd1 vssd1 vccd1 X2_sky130_ef_sc_hd__decap_40_12
XFILLER_40_314 vssd1 vccd1 vccd1 vssd1 X2_sky130_fd_sc_hd__fill_2
XFILLER_71_27 vssd1 vccd1 vssd1 vccd1 X2_sky130_ef_sc_hd__decap_40_12
XFILLER_21_561 vssd1 vccd1 vssd1 vccd1 X2_sky130_ef_sc_hd__decap_40_12
XFILLER_20_53 vssd1 vccd1 vssd1 vccd1 X2_sky130_ef_sc_hd__decap_40_12
XTAP_TAPCELL_ROW_91_1216 vccd1 vssd1 X2_sky130_fd_sc_hd__tapvpwrvgnd_1
XFILLER_0_421 vssd1 vccd1 vssd1 vccd1 X2_sky130_ef_sc_hd__decap_40_12
XFILLER_20_97 vssd1 vccd1 vssd1 vccd1 X2_sky130_ef_sc_hd__decap_40_12
XANTENNA__572__CLK _606_/CLK vssd1 vccd1 vccd1 vssd1 X2_sky130_fd_sc_hd__diode_2
XFILLER_29_51 vssd1 vccd1 vccd1 vssd1 X2_sky130_fd_sc_hd__fill_4
Xhold40 hold40/X _591_/Q vccd1 vssd1 vssd1 vccd1 X2_sky130_fd_sc_hd__dlygate4sd3_1
Xhold62 _563_/D _325_/X vccd1 vssd1 vssd1 vccd1 X2_sky130_fd_sc_hd__dlygate4sd3_1
Xhold51 _550_/D _535_/Q vccd1 vssd1 vssd1 vccd1 X2_sky130_fd_sc_hd__dlygate4sd3_1
XANTENNA_input25_A wbs_dat_i[11] vssd1 vccd1 vccd1 vssd1 X2_sky130_fd_sc_hd__diode_2
Xhold73 hold73/X _600_/Q vccd1 vssd1 vssd1 vccd1 X2_sky130_fd_sc_hd__dlygate4sd3_1
XFILLER_48_469 vccd1 vssd1 vccd1 vssd1 X2_sky130_fd_sc_hd__fill_1
XFILLER_48_458 vccd1 vssd1 vccd1 vssd1 X2_sky130_fd_sc_hd__fill_1
XFILLER_75_277 vssd1 vccd1 vccd1 vssd1 X2_sky130_fd_sc_hd__fill_2
XFILLER_63_417 vssd1 vccd1 vssd1 vccd1 X2_sky130_ef_sc_hd__decap_40_12
Xhold84 hold84/X _574_/Q vccd1 vssd1 vssd1 vccd1 X2_sky130_fd_sc_hd__dlygate4sd3_1
XFILLER_16_333 vssd1 vccd1 vssd1 vccd1 X2_sky130_ef_sc_hd__decap_40_12
XFILLER_28_193 vssd1 vccd1 vccd1 vssd1 X2_sky130_fd_sc_hd__fill_2
X_595_ vssd1 vccd1 vccd1 vssd1 _597_/CLK _595_/D _515_/Y _595_/Q X2_sky130_fd_sc_hd__dfrtp_1
XFILLER_71_461 vssd1 vccd1 vssd1 vccd1 X2_sky130_ef_sc_hd__decap_40_12
XFILLER_16_377 vssd1 vccd1 vssd1 vccd1 X2_sky130_ef_sc_hd__decap_40_12
XTAP_TAPCELL_ROW_100_1323 vccd1 vssd1 X2_sky130_fd_sc_hd__tapvpwrvgnd_1
XFILLER_61_93 vssd1 vccd1 vssd1 vccd1 X2_sky130_ef_sc_hd__decap_40_12
XFILLER_8_587 vccd1 vssd1 vccd1 vssd1 X2_sky130_fd_sc_hd__fill_1
XFILLER_6_77 vssd1 vccd1 vccd1 vssd1 X2_sky130_fd_sc_hd__fill_4
XFILLER_3_281 vssd1 vccd1 vssd1 vccd1 X2_sky130_ef_sc_hd__decap_40_12
XFILLER_79_561 vssd1 vccd1 vssd1 vccd1 X2_sky130_ef_sc_hd__decap_40_12
XANTENNA__429__A2 _553_/D vssd1 vccd1 vccd1 vssd1 X2_sky130_fd_sc_hd__diode_2
XFILLER_20_3 vssd1 vccd1 vssd1 vccd1 X2_sky130_ef_sc_hd__decap_40_12
XFILLER_27_609 vssd1 vccd1 vccd1 vssd1 X2_sky130_fd_sc_hd__fill_4
XFILLER_39_447 vccd1 vssd1 vccd1 vssd1 X2_sky130_fd_sc_hd__fill_1
XFILLER_94_531 vccd1 vssd1 vccd1 vssd1 X2_sky130_fd_sc_hd__fill_1
XFILLER_66_233 vssd1 vccd1 vssd1 vccd1 X2_sky130_ef_sc_hd__decap_40_12
XTAP_TAPCELL_ROW_1_229 vccd1 vssd1 X2_sky130_fd_sc_hd__tapvpwrvgnd_1
XFILLER_66_277 vccd1 vssd1 vccd1 vssd1 X2_sky130_fd_sc_hd__fill_1
XFILLER_54_417 vssd1 vccd1 vccd1 vssd1 X2_sky130_fd_sc_hd__fill_2
XTAP_TAPCELL_ROW_37_626 vccd1 vssd1 X2_sky130_fd_sc_hd__tapvpwrvgnd_1
XFILLER_81_225 vssd1 vccd1 vssd1 vccd1 X2_sky130_ef_sc_hd__decap_40_12
XTAP_TAPCELL_ROW_65_935 vccd1 vssd1 X2_sky130_fd_sc_hd__tapvpwrvgnd_1
XFILLER_47_480 vssd1 vccd1 vssd1 vccd1 X2_sky130_ef_sc_hd__decap_40_12
XFILLER_19_193 vssd1 vccd1 vssd1 vccd1 X2_sky130_ef_sc_hd__decap_40_12
XFILLER_34_141 vssd1 vccd1 vssd1 vccd1 X2_sky130_ef_sc_hd__decap_40_12
XFILLER_50_601 vssd1 vccd1 vccd1 vssd1 X2_sky130_fd_sc_hd__fill_2
XTAP_TAPCELL_ROW_9_318 vccd1 vssd1 X2_sky130_fd_sc_hd__tapvpwrvgnd_1
XTAP_TAPCELL_ROW_77_1071 vccd1 vssd1 X2_sky130_fd_sc_hd__tapvpwrvgnd_1
XFILLER_85_553 vssd1 vccd1 vccd1 vssd1 X2_sky130_fd_sc_hd__fill_4
XFILLER_97_391 vccd1 vssd1 vccd1 vssd1 X2_sky130_fd_sc_hd__fill_1
XFILLER_57_277 vssd1 vccd1 vccd1 vssd1 X2_sky130_fd_sc_hd__fill_2
XFILLER_45_417 vssd1 vccd1 vccd1 vssd1 X2_sky130_fd_sc_hd__fill_8
XFILLER_85_597 vssd1 vccd1 vssd1 vccd1 X2_sky130_ef_sc_hd__decap_40_12
XFILLER_45_428 vssd1 vccd1 vccd1 vssd1 X2_sky130_fd_sc_hd__fill_2
XFILLER_82_15 vssd1 vccd1 vssd1 vccd1 X2_sky130_ef_sc_hd__decap_40_12
XFILLER_53_483 vssd1 vccd1 vssd1 vccd1 X2_sky130_ef_sc_hd__decap_40_12
X_380_ vssd1 vccd1 vssd1 vccd1 _379_/X _411_/A _378_/X _380_/X X2_sky130_fd_sc_hd__o21ba_1
XFILLER_41_612 vccd1 vssd1 vccd1 vssd1 X2_sky130_fd_sc_hd__fill_1
XFILLER_40_133 vssd1 vccd1 vccd1 vssd1 X2_sky130_fd_sc_hd__fill_4
XFILLER_9_329 vssd1 vccd1 vccd1 vssd1 X2_sky130_fd_sc_hd__fill_4
XFILLER_40_177 vssd1 vccd1 vssd1 vccd1 X2_sky130_ef_sc_hd__decap_40_12
XFILLER_21_391 vccd1 vssd1 vccd1 vssd1 X2_sky130_fd_sc_hd__fill_1
XFILLER_5_557 vssd1 vccd1 vccd1 vssd1 X2_sky130_fd_sc_hd__fill_2
Xoutput52 vccd1 vssd1 wbs_dat_o[3] _560_/Q vccd1 vssd1 X2_sky130_fd_sc_hd__buf_2
Xoutput41 vccd1 vssd1 user_irq[0] _628_/X vccd1 vssd1 X2_sky130_fd_sc_hd__buf_2
XFILLER_0_251 vccd1 vssd1 vccd1 vssd1 X2_sky130_fd_sc_hd__fill_1
XFILLER_88_380 vssd1 vccd1 vssd1 vccd1 X2_sky130_ef_sc_hd__decap_40_12
XFILLER_76_531 vccd1 vssd1 vccd1 vssd1 X2_sky130_fd_sc_hd__fill_1
XFILLER_48_233 vssd1 vccd1 vssd1 vccd1 X2_sky130_ef_sc_hd__decap_40_12
XFILLER_36_417 vssd1 vccd1 vccd1 vssd1 X2_sky130_fd_sc_hd__fill_2
XFILLER_91_501 vssd1 vccd1 vccd1 vssd1 X2_sky130_fd_sc_hd__fill_2
XFILLER_48_277 vssd1 vccd1 vccd1 vssd1 X2_sky130_fd_sc_hd__fill_2
XFILLER_36_439 vccd1 vssd1 vccd1 vssd1 X2_sky130_fd_sc_hd__fill_1
XFILLER_63_225 vssd1 vccd1 vssd1 vccd1 X2_sky130_ef_sc_hd__decap_40_12
XFILLER_16_141 vssd1 vccd1 vssd1 vccd1 X2_sky130_ef_sc_hd__decap_40_12
XTAP_TAPCELL_ROW_62_905 vccd1 vssd1 X2_sky130_fd_sc_hd__tapvpwrvgnd_1
XFILLER_44_450 vssd1 vccd1 vssd1 vccd1 X2_sky130_ef_sc_hd__decap_40_12
X_578_ vccd1 vssd1 vccd1 vssd1 _578_/Q _498_/Y _578_/D _597_/CLK X2_sky130_fd_sc_hd__dfstp_1
XFILLER_31_111 vccd1 vssd1 vccd1 vssd1 X2_sky130_fd_sc_hd__fill_1
XFILLER_72_81 vssd1 vccd1 vccd1 vssd1 X2_sky130_fd_sc_hd__fill_2
XTAP_TAPCELL_ROW_14_375 vccd1 vssd1 X2_sky130_fd_sc_hd__tapvpwrvgnd_1
XTAP_TAPCELL_ROW_70_993 vccd1 vssd1 X2_sky130_fd_sc_hd__tapvpwrvgnd_1
XTAP_TAPCELL_ROW_42_684 vccd1 vssd1 X2_sky130_fd_sc_hd__tapvpwrvgnd_1
XFILLER_68_3 vssd1 vccd1 vssd1 vccd1 X2_sky130_ef_sc_hd__decap_40_12
XANTENNA__280__S _289_/S vssd1 vccd1 vccd1 vssd1 X2_sky130_fd_sc_hd__diode_2
XFILLER_98_133 vssd1 vccd1 vccd1 vssd1 X2_sky130_fd_sc_hd__fill_4
XFILLER_98_177 vssd1 vccd1 vssd1 vccd1 X2_sky130_ef_sc_hd__decap_40_12
XFILLER_101_617 vssd1 vccd1 vccd1 vssd1 X2_sky130_fd_sc_hd__fill_8
.ends

.subckt user_project_wrapper analog_io[0] analog_io[10] analog_io[11] analog_io[12]
+ analog_io[13] analog_io[14] analog_io[15] analog_io[16] analog_io[17] analog_io[18]
+ analog_io[19] analog_io[1] analog_io[20] analog_io[21] analog_io[22] analog_io[23]
+ analog_io[24] analog_io[25] analog_io[26] analog_io[27] analog_io[28] analog_io[2]
+ analog_io[3] analog_io[4] analog_io[5] analog_io[6] analog_io[7] analog_io[8] analog_io[9]
+ io_in[0] io_in[10] io_in[11] io_in[12] io_in[13] io_in[14] io_in[15] io_in[16] io_in[17]
+ io_in[18] io_in[19] io_in[1] io_in[20] io_in[21] io_in[22] io_in[23] io_in[24] io_in[25]
+ io_in[26] io_in[27] io_in[28] io_in[29] io_in[2] io_in[30] io_in[31] io_in[32] io_in[33]
+ io_in[34] io_in[35] io_in[36] io_in[37] io_in[3] io_in[4] io_in[5] io_in[6] io_in[7]
+ io_in[8] io_in[9] io_oeb[0] io_oeb[10] io_oeb[11] io_oeb[12] io_oeb[13] io_oeb[14]
+ io_oeb[15] io_oeb[16] io_oeb[17] io_oeb[18] io_oeb[19] io_oeb[1] io_oeb[20] io_oeb[21]
+ io_oeb[22] io_oeb[23] io_oeb[24] io_oeb[25] io_oeb[26] io_oeb[27] io_oeb[28] io_oeb[29]
+ io_oeb[2] io_oeb[30] io_oeb[31] io_oeb[32] io_oeb[33] io_oeb[34] io_oeb[35] io_oeb[36]
+ io_oeb[37] io_oeb[3] io_oeb[4] io_oeb[5] io_oeb[6] io_oeb[7] io_oeb[8] io_oeb[9]
+ io_out[0] io_out[10] io_out[11] io_out[12] io_out[13] io_out[14] io_out[15] io_out[16]
+ io_out[17] io_out[18] io_out[19] io_out[1] io_out[20] io_out[21] io_out[22] io_out[23]
+ io_out[24] io_out[25] io_out[26] io_out[27] io_out[28] io_out[29] io_out[2] io_out[30]
+ io_out[31] io_out[32] io_out[33] io_out[34] io_out[35] io_out[36] io_out[37] io_out[3]
+ io_out[4] io_out[5] io_out[6] io_out[7] io_out[8] io_out[9] la_data_in[0] la_data_in[100]
+ la_data_in[101] la_data_in[102] la_data_in[103] la_data_in[104] la_data_in[105]
+ la_data_in[106] la_data_in[107] la_data_in[108] la_data_in[109] la_data_in[10] la_data_in[110]
+ la_data_in[111] la_data_in[112] la_data_in[113] la_data_in[114] la_data_in[115]
+ la_data_in[116] la_data_in[117] la_data_in[118] la_data_in[119] la_data_in[11] la_data_in[120]
+ la_data_in[121] la_data_in[122] la_data_in[123] la_data_in[124] la_data_in[125]
+ la_data_in[126] la_data_in[127] la_data_in[12] la_data_in[13] la_data_in[14] la_data_in[15]
+ la_data_in[16] la_data_in[17] la_data_in[18] la_data_in[19] la_data_in[1] la_data_in[20]
+ la_data_in[21] la_data_in[22] la_data_in[23] la_data_in[24] la_data_in[25] la_data_in[26]
+ la_data_in[27] la_data_in[28] la_data_in[29] la_data_in[2] la_data_in[30] la_data_in[31]
+ la_data_in[32] la_data_in[33] la_data_in[34] la_data_in[35] la_data_in[36] la_data_in[37]
+ la_data_in[38] la_data_in[39] la_data_in[3] la_data_in[40] la_data_in[41] la_data_in[42]
+ la_data_in[43] la_data_in[44] la_data_in[45] la_data_in[46] la_data_in[47] la_data_in[48]
+ la_data_in[49] la_data_in[4] la_data_in[50] la_data_in[51] la_data_in[52] la_data_in[53]
+ la_data_in[54] la_data_in[55] la_data_in[56] la_data_in[57] la_data_in[58] la_data_in[59]
+ la_data_in[5] la_data_in[60] la_data_in[61] la_data_in[62] la_data_in[63] la_data_in[64]
+ la_data_in[65] la_data_in[66] la_data_in[67] la_data_in[68] la_data_in[69] la_data_in[6]
+ la_data_in[70] la_data_in[71] la_data_in[72] la_data_in[73] la_data_in[74] la_data_in[75]
+ la_data_in[76] la_data_in[77] la_data_in[78] la_data_in[79] la_data_in[7] la_data_in[80]
+ la_data_in[81] la_data_in[82] la_data_in[83] la_data_in[84] la_data_in[85] la_data_in[86]
+ la_data_in[87] la_data_in[88] la_data_in[89] la_data_in[8] la_data_in[90] la_data_in[91]
+ la_data_in[92] la_data_in[93] la_data_in[94] la_data_in[95] la_data_in[96] la_data_in[97]
+ la_data_in[98] la_data_in[99] la_data_in[9] la_data_out[0] la_data_out[100] la_data_out[101]
+ la_data_out[102] la_data_out[103] la_data_out[104] la_data_out[105] la_data_out[106]
+ la_data_out[107] la_data_out[108] la_data_out[109] la_data_out[10] la_data_out[110]
+ la_data_out[111] la_data_out[112] la_data_out[113] la_data_out[114] la_data_out[115]
+ la_data_out[116] la_data_out[117] la_data_out[118] la_data_out[119] la_data_out[11]
+ la_data_out[120] la_data_out[121] la_data_out[122] la_data_out[123] la_data_out[124]
+ la_data_out[125] la_data_out[126] la_data_out[127] la_data_out[12] la_data_out[13]
+ la_data_out[14] la_data_out[15] la_data_out[16] la_data_out[17] la_data_out[18]
+ la_data_out[19] la_data_out[1] la_data_out[20] la_data_out[21] la_data_out[22] la_data_out[23]
+ la_data_out[24] la_data_out[25] la_data_out[26] la_data_out[27] la_data_out[28]
+ la_data_out[29] la_data_out[2] la_data_out[30] la_data_out[31] la_data_out[32] la_data_out[33]
+ la_data_out[34] la_data_out[35] la_data_out[36] la_data_out[37] la_data_out[38]
+ la_data_out[39] la_data_out[3] la_data_out[40] la_data_out[41] la_data_out[42] la_data_out[43]
+ la_data_out[44] la_data_out[45] la_data_out[46] la_data_out[47] la_data_out[48]
+ la_data_out[49] la_data_out[4] la_data_out[50] la_data_out[51] la_data_out[52] la_data_out[53]
+ la_data_out[54] la_data_out[55] la_data_out[56] la_data_out[57] la_data_out[58]
+ la_data_out[59] la_data_out[5] la_data_out[60] la_data_out[61] la_data_out[62] la_data_out[63]
+ la_data_out[64] la_data_out[65] la_data_out[66] la_data_out[67] la_data_out[68]
+ la_data_out[69] la_data_out[6] la_data_out[70] la_data_out[71] la_data_out[72] la_data_out[73]
+ la_data_out[74] la_data_out[75] la_data_out[76] la_data_out[77] la_data_out[78]
+ la_data_out[79] la_data_out[7] la_data_out[80] la_data_out[81] la_data_out[82] la_data_out[83]
+ la_data_out[84] la_data_out[85] la_data_out[86] la_data_out[87] la_data_out[88]
+ la_data_out[89] la_data_out[8] la_data_out[90] la_data_out[91] la_data_out[92] la_data_out[93]
+ la_data_out[94] la_data_out[95] la_data_out[96] la_data_out[97] la_data_out[98]
+ la_data_out[99] la_data_out[9] la_oenb[0] la_oenb[100] la_oenb[101] la_oenb[102]
+ la_oenb[103] la_oenb[104] la_oenb[105] la_oenb[106] la_oenb[107] la_oenb[108] la_oenb[109]
+ la_oenb[10] la_oenb[110] la_oenb[111] la_oenb[112] la_oenb[113] la_oenb[114] la_oenb[115]
+ la_oenb[116] la_oenb[117] la_oenb[118] la_oenb[119] la_oenb[11] la_oenb[120] la_oenb[121]
+ la_oenb[122] la_oenb[123] la_oenb[124] la_oenb[125] la_oenb[126] la_oenb[127] la_oenb[12]
+ la_oenb[13] la_oenb[14] la_oenb[15] la_oenb[16] la_oenb[17] la_oenb[18] la_oenb[19]
+ la_oenb[1] la_oenb[20] la_oenb[21] la_oenb[22] la_oenb[23] la_oenb[24] la_oenb[25]
+ la_oenb[26] la_oenb[27] la_oenb[28] la_oenb[29] la_oenb[2] la_oenb[30] la_oenb[31]
+ la_oenb[32] la_oenb[33] la_oenb[34] la_oenb[35] la_oenb[36] la_oenb[37] la_oenb[38]
+ la_oenb[39] la_oenb[3] la_oenb[40] la_oenb[41] la_oenb[42] la_oenb[43] la_oenb[44]
+ la_oenb[45] la_oenb[46] la_oenb[47] la_oenb[48] la_oenb[49] la_oenb[4] la_oenb[50]
+ la_oenb[51] la_oenb[52] la_oenb[53] la_oenb[54] la_oenb[55] la_oenb[56] la_oenb[57]
+ la_oenb[58] la_oenb[59] la_oenb[5] la_oenb[60] la_oenb[61] la_oenb[62] la_oenb[63]
+ la_oenb[64] la_oenb[65] la_oenb[66] la_oenb[67] la_oenb[68] la_oenb[69] la_oenb[6]
+ la_oenb[70] la_oenb[71] la_oenb[72] la_oenb[73] la_oenb[74] la_oenb[75] la_oenb[76]
+ la_oenb[77] la_oenb[78] la_oenb[79] la_oenb[7] la_oenb[80] la_oenb[81] la_oenb[82]
+ la_oenb[83] la_oenb[84] la_oenb[85] la_oenb[86] la_oenb[87] la_oenb[88] la_oenb[89]
+ la_oenb[8] la_oenb[90] la_oenb[91] la_oenb[92] la_oenb[93] la_oenb[94] la_oenb[95]
+ la_oenb[96] la_oenb[97] la_oenb[98] la_oenb[99] la_oenb[9] user_clock2 user_irq[0]
+ user_irq[1] user_irq[2] vccd1 vccd2 vdda1 vdda2 vssa1 vssa2 vssd1 vssd2 wb_clk_i
+ wb_rst_i wbs_ack_o wbs_adr_i[0] wbs_adr_i[10] wbs_adr_i[11] wbs_adr_i[12] wbs_adr_i[13]
+ wbs_adr_i[14] wbs_adr_i[15] wbs_adr_i[16] wbs_adr_i[17] wbs_adr_i[18] wbs_adr_i[19]
+ wbs_adr_i[1] wbs_adr_i[20] wbs_adr_i[21] wbs_adr_i[22] wbs_adr_i[23] wbs_adr_i[24]
+ wbs_adr_i[25] wbs_adr_i[26] wbs_adr_i[27] wbs_adr_i[28] wbs_adr_i[29] wbs_adr_i[2]
+ wbs_adr_i[30] wbs_adr_i[31] wbs_adr_i[3] wbs_adr_i[4] wbs_adr_i[5] wbs_adr_i[6]
+ wbs_adr_i[7] wbs_adr_i[8] wbs_adr_i[9] wbs_cyc_i wbs_dat_i[0] wbs_dat_i[10] wbs_dat_i[11]
+ wbs_dat_i[12] wbs_dat_i[13] wbs_dat_i[14] wbs_dat_i[15] wbs_dat_i[16] wbs_dat_i[17]
+ wbs_dat_i[18] wbs_dat_i[19] wbs_dat_i[1] wbs_dat_i[20] wbs_dat_i[21] wbs_dat_i[22]
+ wbs_dat_i[23] wbs_dat_i[24] wbs_dat_i[25] wbs_dat_i[26] wbs_dat_i[27] wbs_dat_i[28]
+ wbs_dat_i[29] wbs_dat_i[2] wbs_dat_i[30] wbs_dat_i[31] wbs_dat_i[3] wbs_dat_i[4]
+ wbs_dat_i[5] wbs_dat_i[6] wbs_dat_i[7] wbs_dat_i[8] wbs_dat_i[9] wbs_dat_o[0] wbs_dat_o[10]
+ wbs_dat_o[11] wbs_dat_o[12] wbs_dat_o[13] wbs_dat_o[14] wbs_dat_o[15] wbs_dat_o[16]
+ wbs_dat_o[17] wbs_dat_o[18] wbs_dat_o[19] wbs_dat_o[1] wbs_dat_o[20] wbs_dat_o[21]
+ wbs_dat_o[22] wbs_dat_o[23] wbs_dat_o[24] wbs_dat_o[25] wbs_dat_o[26] wbs_dat_o[27]
+ wbs_dat_o[28] wbs_dat_o[29] wbs_dat_o[2] wbs_dat_o[30] wbs_dat_o[31] wbs_dat_o[3]
+ wbs_dat_o[4] wbs_dat_o[5] wbs_dat_o[6] wbs_dat_o[7] wbs_dat_o[8] wbs_dat_o[9] wbs_sel_i[0]
+ wbs_sel_i[1] wbs_sel_i[2] wbs_sel_i[3] wbs_stb_i wbs_we_i
Xmprj io_in[0] io_in[10] io_in[11] io_in[1] io_in[2] io_in[3] io_in[4] io_in[5] io_in[6]
+ io_in[7] io_in[8] io_in[9] user_irq[0] user_irq[1] user_irq[2] vccd2 wb_clk_i wb_rst_i
+ wbs_ack_o wbs_adr_i[0] wbs_adr_i[10] wbs_adr_i[11] wbs_adr_i[12] wbs_adr_i[13] wbs_adr_i[14]
+ wbs_adr_i[15] wbs_adr_i[16] wbs_adr_i[17] wbs_adr_i[18] wbs_adr_i[19] wbs_adr_i[1]
+ wbs_adr_i[20] wbs_adr_i[21] wbs_adr_i[22] wbs_adr_i[23] wbs_adr_i[24] wbs_adr_i[25]
+ wbs_adr_i[26] wbs_adr_i[27] wbs_adr_i[28] wbs_adr_i[29] wbs_adr_i[2] wbs_adr_i[30]
+ wbs_adr_i[31] wbs_adr_i[3] wbs_adr_i[4] wbs_adr_i[5] wbs_adr_i[6] wbs_adr_i[7] wbs_adr_i[8]
+ wbs_adr_i[9] wbs_cyc_i wbs_dat_i[0] wbs_dat_i[10] wbs_dat_i[11] wbs_dat_i[12] wbs_dat_i[13]
+ wbs_dat_i[14] wbs_dat_i[15] wbs_dat_i[16] wbs_dat_i[17] wbs_dat_i[18] wbs_dat_i[19]
+ wbs_dat_i[1] wbs_dat_i[20] wbs_dat_i[21] wbs_dat_i[22] wbs_dat_i[23] wbs_dat_i[24]
+ wbs_dat_i[25] wbs_dat_i[26] wbs_dat_i[27] wbs_dat_i[28] wbs_dat_i[29] wbs_dat_i[2]
+ wbs_dat_i[30] wbs_dat_i[31] wbs_dat_i[3] wbs_dat_i[4] wbs_dat_i[5] wbs_dat_i[6]
+ wbs_dat_i[7] wbs_dat_i[8] wbs_dat_i[9] wbs_dat_o[0] wbs_dat_o[10] wbs_dat_o[11]
+ wbs_dat_o[12] wbs_dat_o[13] wbs_dat_o[14] wbs_dat_o[15] wbs_dat_o[16] wbs_dat_o[17]
+ wbs_dat_o[18] wbs_dat_o[19] wbs_dat_o[1] wbs_dat_o[20] wbs_dat_o[21] wbs_dat_o[22]
+ wbs_dat_o[23] wbs_dat_o[24] wbs_dat_o[25] wbs_dat_o[26] wbs_dat_o[27] wbs_dat_o[28]
+ wbs_dat_o[29] wbs_dat_o[2] wbs_dat_o[30] wbs_dat_o[31] wbs_dat_o[3] wbs_dat_o[4]
+ wbs_dat_o[5] wbs_dat_o[6] wbs_dat_o[7] wbs_dat_o[8] wbs_dat_o[9] wbs_sel_i[0] wbs_sel_i[1]
+ wbs_sel_i[2] wbs_sel_i[3] wbs_stb_i wbs_we_i vssd2 top_soc
.ends
